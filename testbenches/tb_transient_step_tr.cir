* TB7: Small-Signal Step Response (Transistor-Level LM741)
.include "../models/lm741_transistor_level.sub"

Vcc vcc 0 DC 15
Vee vee 0 DC -15

Vin in_p 0 PULSE(0 100m 1u 1n 1n 10u 20u)

X1 in_p out vcc vee out LM741_TRANSISTOR

RL out 0 2k
CL out 0 100p

.tran 0 15u 0 10n

.meas tran V_peak max V(out)
.meas tran Overshoot_pct param ((V_peak - 100m) / 100m) * 100.0
.meas tran t10 when V(out)=10m rise=1
.meas tran t90 when V(out)=90m rise=1
.meas tran Trise_ns param (t90 - t10) * 1e9

.end
