* TB11: Equivalent Input Noise Voltage Density (en)
.include "../models/lm741_transistor_level.sub"

Vcc vcc 0 DC 15
Vee vee 0 DC -15

Vin in_p 0 DC 0 AC 1.0

* Non-inverting gain = 10 (Rf=9k, Rg=1k)
Rf out in_m 9k
Rg in_m 0 1k

X1 in_p in_m vcc vee out LM741_TRANSISTOR

RL out 0 2k
CL out 0 100p

.noise V(out) Vin dec 10 10 100k

* Measure equivalent input noise density at 1 kHz
.meas noise E_noise_1k find V(inoise) at=1k
.meas noise E_noise_1k_nV param E_noise_1k * 1e9

.end
