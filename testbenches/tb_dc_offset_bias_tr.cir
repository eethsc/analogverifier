* TB5: DC Offset, Bias Currents, and Supply Current (Transistor-Level LM741)
.include "../models/lm741_transistor_level.sub"

Vcc vcc 0 DC 15
Vee vee 0 DC -15

* Sensing sources (0V)
V_zero_p 0 in_p DC 0
V_zero_m out in_m DC 0

* Follower
X1 in_p in_m vcc vee out LM741_TRANSISTOR

.op

.meas op Vos_mV param abs(V(out)) * 1000
.meas op Ib_p_nA param abs(I(V_zero_p)) * 1e9
.meas op Ib_m_nA param abs(I(V_zero_m)) * 1e9
.meas op Ib_avg_nA param (abs(I(V_zero_p)) + abs(I(V_zero_m))) * 0.5 * 1e9
.meas op Ios_nA param abs(abs(I(V_zero_p)) - abs(I(V_zero_m))) * 1e9
.meas op Iq_mA param -I(Vcc) * 1e3

.end
