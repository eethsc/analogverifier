* TB6: Output Voltage Swing (Transistor-Level LM741)
.include "../models/lm741_transistor_level.sub"

Vcc vcc 0 DC 15
Vee vee 0 DC -15

Vin in_p 0 DC 0

Rf out in_m 10k
Rg in_m 0 10k

X1 in_p in_m vcc vee out LM741_TRANSISTOR

RL out 0 2k
CL out 0 100p

.dc Vin -15 15 0.1

.meas dc Vom_pos max V(out)
.meas dc Vom_neg min V(out)

.end
