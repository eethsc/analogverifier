* TB3: Common-Mode Rejection Ratio (CMRR) Testbench
* Measures: CMRR at DC/low frequency (10 Hz)

.include "../models/lm741_macromodel.sub"

* Power Supplies
Vcc vcc 0 DC 15
Vee vee 0 DC -15

* Common-Mode AC input (1V AC)
Vin in_cm 0 DC 0 AC 1.0

* Unity Gain Follower with Common Mode input
X1 in_cm out vcc vee out LM741_MACRO

* Load
RL out 0 2k
CL out 0 100p

.ac dec 10 1 1Meg

* Measurement: In unity-gain buffer, input-referred common mode error is V(in_cm) - V(out)
* CMRR = V(in_cm) / |V(in_cm) - V(out)|
* Since V(in_cm) = 1.0, CMRR = 1 / |V(in_cm) - V(out)|
.meas ac V_diff_cm find mag(V(in_cm) - V(out)) at=10
.meas ac CMRR_dB param -20 * log10(V_diff_cm)

.end
