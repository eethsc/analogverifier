* TB1: AC Open-Loop Frequency Response
* Measures: Open-Loop DC Gain (Avol), Unity-Gain Bandwidth (GBW), Phase Margin (PM)

.include "../models/lm741_macromodel.sub"

* Power Supplies
Vcc vcc 0 DC 15
Vee vee 0 DC -15

* Input AC source at IN+
Vin in_p 0 DC 0 AC 1.0

* L-C Servo loop for stable DC operating point and AC open-loop:
* L_fb provides negative feedback at DC (short) to keep amplifier in linear region
* C_fb provides AC ground (short at AC) to open the loop for AC analysis
L_fb out in_m 100Meg
C_fb in_m 0 100Meg

* DUT Instance
* Pins: IN+ IN- VCC VEE OUT
X1 in_p in_m vcc vee out LM741_MACRO

* Load: 2k ohm, 100pF
RL out 0 2k
CL out 0 100p

.ac dec 20 0.01 100Meg

* Measurements
* 1. DC Open-Loop Gain and Phase at 1 Hz
.meas ac Avol_at_1Hz find V(out) at=1

* 2. Unity Gain Bandwidth (GBW) where loop gain magnitude is 1.0 (0 dB)
.meas ac GBW when mag(V(out))=1.0

* 3. Loop response at GBW (contains loop phase)
.meas ac Loop_at_GBW find V(out) when mag(V(out))=1.0

.end
