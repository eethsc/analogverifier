* Full Datasheet Audit Testbench (Input/Output Impedance, Short-Circuit Current, VICR)
.include "../models/lm741_transistor_level.sub"

* --- 1. Differential Input Resistance (ri) ---
Vcc1 vcc1 0 DC 15
Vee1 vee1 0 DC -15
Vin_diff in_p1 in_m1 DC 0 AC 1.0
R_cm_mid in_m1 0 1Meg
* Follower DC bias
L_fb1 out1 in_m1 100Meg
C_fb1 in_m1 0 100Meg
X_rin in_p1 in_m1 vcc1 vee1 out1 LM741_TRANSISTOR
RL1 out1 0 2k

* --- 2. Positive Short-Circuit Current (Isc+) ---
Vcc2 vcc2 0 DC 15
Vee2 vee2 0 DC -15
Vin_sc_p in_p2 0 DC 1.0
X_sc_p in_p2 0 vcc2 vee2 out_sc_p LM741_TRANSISTOR
V_short_p out_sc_p 0 DC 0

* --- 3. Negative Short-Circuit Current (Isc-) ---
Vcc3 vcc3 0 DC 15
Vee3 vee3 0 DC -15
Vin_sc_m in_p3 0 DC -1.0
X_sc_m in_p3 0 vcc3 vee3 out_sc_m LM741_TRANSISTOR
V_short_m out_sc_m 0 DC 0

* --- 4. Common-Mode Input Voltage Range (VICR) ---
Vcc4 vcc4 0 DC 15
Vee4 vee4 0 DC -15
Vin_cm in_cm 0 DC 0
X_vicr in_cm out_cm vcc4 vee4 out_cm LM741_TRANSISTOR
RL4 out_cm 0 2k

.op
.meas op I_in_mag find I(Vin_diff)
.meas op Rin_MOhm param 1.0 / (abs(I_in_mag) * 1e6)
.meas op Isc_pos_mA find I(V_short_p) * 1e3
.meas op Isc_neg_mA find -I(V_short_m) * 1e3

.end
