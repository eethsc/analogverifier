* TB4: Power Supply Rejection Ratio (Transistor-Level LM741)
.include "../models/lm741_transistor_level.sub"

* --- Positive Rail PSRR Testbench ---
Vcc_p vcc_p 0 DC 15 AC 1.0
Vee_p vee_p 0 DC -15 AC 0.0
X_pos 0 out_p vcc_p vee_p out_p LM741_TRANSISTOR
RL_p out_p 0 2k

* --- Negative Rail PSRR Testbench ---
Vcc_n vcc_n 0 DC 15 AC 0.0
Vee_n vee_n 0 DC -15 AC 1.0
X_neg 0 out_n vcc_n vee_n out_n LM741_TRANSISTOR
RL_n out_n 0 2k

.ac dec 10 1 1Meg

.meas ac V_ripple_p find mag(V(out_p)) at=10
.meas ac V_ripple_n find mag(V(out_n)) at=10

.end
