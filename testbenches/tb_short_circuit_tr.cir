* TB9: Output Short-Circuit Protection Current (Isc+ and Isc-)
.include "../models/lm741_transistor_level.sub"

* --- Positive Sourcing Short-Circuit Current ---
Vcc1 vcc1 0 DC 15
Vee1 vee1 0 DC -15
Vin1 in_p1 0 DC 1.0
X1 in_p1 0 vcc1 vee1 out1 LM741_TRANSISTOR
V_short1 out1 0 DC 0

* --- Negative Sinking Short-Circuit Current ---
Vcc2 vcc2 0 DC 15
Vee2 vee2 0 DC -15
Vin2 in_p2 0 DC -1.0
X2 in_p2 0 vcc2 vee2 out2 LM741_TRANSISTOR
V_short2 out2 0 DC 0

.op

.meas op Isc_pos_mA find I(V_short1) * 1e3
.meas op Isc_neg_mA find -I(V_short2) * 1e3

.end
