* TB3: Common-Mode Rejection Ratio (Transistor-Level LM741)
.include "../models/lm741_transistor_level.sub"

Vcc vcc 0 DC 15
Vee vee 0 DC -15

Vin in_cm 0 DC 0 AC 1.0

* Unity Gain Follower with Common Mode input
X1 in_cm out vcc vee out LM741_TRANSISTOR

RL out 0 2k
CL out 0 100p

.ac dec 10 1 1Meg

.meas ac V_diff_cm find mag(V(in_cm) - V(out)) at=10

.end
