* TB5: DC Offset, Bias Currents, and Quiescent Current
* Measures: Vos (mV), Ib (nA), Ios (nA), Iq (mA)

.include "../models/lm741_macromodel.sub"

* Power Supplies
Vcc vcc 0 DC 15
Vee vee 0 DC -15

* Input 0V sensing sources to measure bias current directly
V_zero_p 0 in_p DC 0
V_zero_m out in_m DC 0

* DUT in unity-gain follower (out tied to in_m through V_zero_m)
X1 in_p in_m vcc vee out LM741_MACRO

* No external load for Iq measurement

.op

* Offset Voltage: In unity buffer with 0V input, V(out) = Vos
.meas op Vos_mV param abs(V(out)) * 1000

* Input Bias currents (in nA)
.meas op Ib_p_nA param abs(I(V_zero_p)) * 1e9
.meas op Ib_m_nA param abs(I(V_zero_m)) * 1e9
.meas op Ib_avg_nA param (abs(I(V_zero_p)) + abs(I(V_zero_m))) * 0.5 * 1e9
.meas op Ios_nA param abs(abs(I(V_zero_p)) - abs(I(V_zero_m))) * 1e9

* Quiescent Current (in mA)
.meas op Iq_mA param -I(Vcc) * 1e3

.end
