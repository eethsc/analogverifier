* CDCVF2505-Q1 High-Performance, Low-Skew, Low-Jitter PLL Clock Driver
* Synthesized by an autonomous AI Analog Circuit Architect
* Date: 2023-10-27

.subckt CDCVF2505_Q1 CLKIN 1Y1 1Y0 GND 1Y2 VDD_3_3_V 1Y3 CLKOUT

* --- Global Power and Ground Connections ---
.param VDD_NOM = 3.3V
.param VDD_MIN = 3.0V
.param VDD_MAX = 3.6V
.param TEMP_NOM = 27
.param TEMP_MIN = -40
.param TEMP_MAX = 85

* --- Model Definitions (Generic CMOS and Diode Models) ---
* NMOS Model: Level 1, typical parameters for 0.35um process (adjust as needed)
.model NMOS NMOS (LEVEL=1 VTO=0.7 KP=120u GAMMA=0.4 PHI=0.6 LAMBDA=0.05
+ TOX=7n UO=400 NSUB=1e16 PB=0.8 CJ=0.5m CJSW=0.2p MJ=0.5 MJSW=0.3)
* PMOS Model: Level 1, typical parameters for 0.35um process (adjust as needed)
.model PMOS PMOS (LEVEL=1 VTO=-0.7 KP=40u GAMMA=0.5 PHI=0.6 LAMBDA=0.06
+ TOX=7n UO=150 NSUB=1e16 PB=0.8 CJ=0.8m CJSW=0.2p MJ=0.5 MJSW=0.3)
* Diode Model: For ESD protection and clamping
.model D_ESD D (IS=1e-14 N=1 RS=1 CJO=1p TT=1n BV=50 IBV=1u)

* --- ESD Protection Diodes for all pins ---
* CLKIN ESD
D_CLKIN_P CLKIN VDD_3_3_V D_ESD
D_CLKIN_N GND CLKIN D_ESD
* 1Y1 ESD
D_1Y1_P 1Y1 VDD_3_3_V D_ESD
D_1Y1_N GND 1Y1 D_ESD
* 1Y0 ESD
D_1Y0_P 1Y0 VDD_3_3_V D_ESD
D_1Y0_N GND 1Y0 D_ESD
* 1Y2 ESD
D_1Y2_P 1Y2 VDD_3_3_V D_ESD
D_1Y2_N GND 1Y2 D_ESD
* 1Y3 ESD
D_1Y3_P 1Y3 VDD_3_3_V D_ESD
D_1Y3_N GND 1Y3 D_ESD
* CLKOUT ESD
D_CLKOUT_P CLKOUT VDD_3_3_V D_ESD
D_CLKOUT_N GND CLKOUT D_ESD

* --- Input Buffer (Schmitt Trigger for CLKIN) ---
* Provides hysteresis and cleans up input signal.
* VIH = 0.7 * VDD, VIL = 0.3 * VDD
* For VDD=3.3V, VIH = 2.31V, VIL = 0.99V
* Hysteresis = 1.32V
* Ci = 4.2 pF (modeled by input capacitance of Schmitt trigger + ESD diodes)
C_CLKIN_IN CLKIN 0 4.2p ; Input capacitance

B_SCHMITT_OUT clkin_buf_out GND V = { V(CLKIN) > (0.7 * V(VDD_3_3_V)) ? V(VDD_3_3_V) : ( V(CLKIN) < (0.3 * V(VDD_3_3_V)) ? 0 : ( V(clkin_buf_out) > (0.5 * V(VDD_3_3_V)) ? V(VDD_3_3_V) : 0 )) }
* Add a small delay to the Schmitt trigger output
R_SCHMITT_DELAY clkin_buf_out clkin_int 100
C_SCHMITT_DELAY clkin_int GND 10p

* --- Power-Down Detection (CLKIN absence) ---
* Detects if CLKIN is active. If not, PLL and outputs are powered down.
* This is a simplified behavioral model. A real circuit would use an edge detector and timer.
* Power-down if CLKIN is stable (no transitions) for a certain period.
B_CLKIN_ACTIVITY clkin_activity GND V = { abs(ddt(V(CLKIN))) > 100m ? V(VDD_3_3_V) : 0 }
* Use a low-pass filter to detect sustained activity
R_PD_LPF clkin_activity pd_filter_node 10k
C_PD_LPF pd_filter_node GND 100n ; Time constant for activity detection
* If pd_filter_node is low for a while, power_down_en goes high (active low enable)
B_POWER_DOWN_EN power_down_en GND V = { V(pd_filter_node) < (0.1 * V(VDD_3_3_V)) ? V(VDD_3_3_V) : 0 }
* Invert power_down_en to get active high PLL_ENABLE
B_PLL_ENABLE pll_enable GND V = { V(power_down_en) > (0.5 * V(VDD_3_3_V)) ? 0 : V(VDD_3_3_V) }

* --- Phase-Locked Loop (PLL) Core ---
* Consists of PFD, Charge Pump, Loop Filter, VCO, and Feedback Divider (N=1)
* Stabilization time: Max 100 us

* 1. Phase Frequency Detector (PFD)
* Behavioral PFD: Outputs UP/DOWN pulses based on phase difference.
* clkin_int is reference, clkout_fb is feedback.
B_PFD_UP pfd_up GND V = { (V(pll_enable) > 0.5*V(VDD_3_3_V)) & (V(clkin_int) > 0.5*V(VDD_3_3_V) & ddt(V(clkin_int)) > 0) & (V(clkout_fb) < 0.5*V(VDD_3_3_V) | ddt(V(clkout_fb)) < 0) ? V(VDD_3_3_V) : 0 }
B_PFD_DOWN pfd_down GND V = { (V(pll_enable) > 0.5*V(VDD_3_3_V)) & (V(clkout_fb) > 0.5*V(VDD_3_3_V) & ddt(V(clkout_fb)) > 0) & (V(clkin_int) < 0.5*V(VDD_3_3_V) | ddt(V(clkin_int)) < 0) ? V(VDD_3_3_V) : 0 }

* 2. Charge Pump (CP)
* Converts UP/DOWN pulses to current for loop filter.
* Icp = 500uA (example value, tuned for stabilization time)
.param Icp = 500u
G_CP_UP VDD_3_3_V vco_ctrl_node VALUE = { (V(pfd_up) > 0.5*V(VDD_3_3_V)) ? Icp : 0 }
G_CP_DOWN vco_ctrl_node VDD_3_3_V VALUE = { (V(pfd_down) > 0.5*V(VDD_3_3_V)) ? Icp : 0 }

* 3. Loop Filter (LF) - Type II Passive Filter
* R_LF and C_LF values chosen for stability and 100us stabilization time.
* Target BW_L ~ 10kHz (for 100us settling)
* K_VCO = (200MHz - 24MHz) / (2.8V - 0.5V) = 176MHz / 2.3V = 76.5 MHz/V
* K_PFD = Icp / (2*pi) = 500uA / (2*pi) = 79.5 uA/rad
* For N=1, BW_L = sqrt(K_PFD * K_VCO / C_LF) * sqrt(1 + (R_LF * C_LF * BW_L)^2)
* Simplified: C_LF ~ K_PFD * K_VCO / (BW_L^2)
* R_LF ~ 1 / (BW_L * C_LF) for phase margin
.param C_LF_VAL = 10n ; Tuned for 100us stabilization
.param R_LF_VAL = 1k   ; Tuned for phase margin
R_LF vco_ctrl_node vco_ctrl_filt {R_LF_VAL}
C_LF vco_ctrl_filt GND {C_LF_VAL}

* 4. Voltage Controlled Oscillator (VCO)
* Frequency range: 24 MHz to 200 MHz
* Control voltage range: 0.5V to 2.8V (example, typical for CMOS VCO)
* K_VCO = (200M - 24M) / (2.8 - 0.5) = 76.5 MHz/V
* VCO output is a square wave.
B_VCO_FREQ vco_freq_inst GND V = { (V(vco_ctrl_filt) < 0.5) ? 24M : ( (V(vco_ctrl_filt) > 2.8) ? 200M : ( 24M + (V(vco_ctrl_filt) - 0.5) * 76.5M )) }
B_VCO_OUT vco_out GND V = { (V(pll_enable) > 0.5*V(VDD_3_3_V)) ? ( (sin(2*pi*V(vco_freq_inst)*time) > 0) ? V(VDD_3_3_V) : 0 ) : 0 }
* Add some intrinsic VCO jitter (behavioral)
R_VCO_JITTER vco_out vco_out_jitter 10
C_VCO_JITTER vco_out_jitter GND 10p
V_JITTER_NOISE vco_out_jitter_noise GND SINE(0 10m 10k 0 0 0) AC 1n
R_JITTER_INJECT vco_out_jitter_noise vco_out_jitter 10k

* --- Duty Cycle Corrector (DCC) ---
* Ensures 50% output duty cycle. This is a behavioral model.
* The VCO output is already 50% duty cycle. This block ensures the output buffers maintain it.
* For simplicity, we assume the VCO output is already 50% and buffers are balanced.
* If CLKIN duty cycle is outside 40-60% (for >86MHz) or 30-85% (for 24-85MHz), the PLL still outputs 50%.
B_DCC_OUT dcc_out GND V = { V(vco_out) }

* --- Output Buffers (1Y0, 1Y1, 1Y2, 1Y3, CLKOUT) ---
* Each 1Yx output has an integrated 25-ohm series damping resistor.
* CLKOUT is for feedback, no series resistor.
* Co = 2.8 pF for 1Yx, 5.2 pF for CLKOUT (modeled by output capacitance of buffer + ESD diodes)
* Output drive strength: IOH/IOL = 12mA min.
* Rise/Fall time: 0.5ns to 2.0ns for 25pF load.

* Output Buffer Subcircuit (reusable)
* Parameters: R_SERIES (series damping resistor), C_OUT (output capacitance)
.subckt OUTPUT_BUFFER IN OUT VDD GND R_SERIES C_OUT_VAL
* Output stage for high current drive
M_P_OUT OUT IN VDD VDD PMOS W=100u L=0.35u
M_N_OUT OUT IN GND GND NMOS W=50u L=0.35u
C_OUT OUT GND {C_OUT_VAL}
R_DAMP OUT_INT OUT {R_SERIES} ; Series damping resistor
.ends OUTPUT_BUFFER

* CLKOUT (Feedback Output)
* Co = 5.2 pF
* No series damping resistor for CLKOUT
X_CLKOUT_BUF dcc_out clkout_int VDD_3_3_V GND 0 5.2p OUTPUT_BUFFER
* CLKOUT is the feedback signal for the PLL
R_CLKOUT_DELAY clkout_int clkout_fb 50p ; Small delay for feedback path
C_CLKOUT_FB clkout_fb GND 5.2p ; Feedback capacitance
* Final CLKOUT pin connection
R_CLKOUT_PIN clkout_int CLKOUT 10 ; Small series R to represent package/trace
C_CLKOUT_PIN CLKOUT GND 5.2p ; Pin capacitance

* 1Y0 Output
* Co = 2.8 pF, R_SERIES = 25 Ohm
X_1Y0_BUF dcc_out 1Y0_int VDD_3_3_V GND 25 2.8p OUTPUT_BUFFER
R_1Y0_PIN 1Y0_int 1Y0 10 ; Small series R to represent package/trace
C_1Y0_PIN 1Y0 GND 2.8p ; Pin capacitance

* 1Y1 Output
* Co = 2.8 pF, R_SERIES = 25 Ohm
X_1Y1_BUF dcc_out 1Y1_int VDD_3_3_V GND 25 2.8p OUTPUT_BUFFER
R_1Y1_PIN 1Y1_int 1Y1 10 ; Small series R to represent package/trace
C_1Y1_PIN 1Y1 GND 2.8p ; Pin capacitance

* 1Y2 Output
* Co = 2.8 pF, R_SERIES = 25 Ohm
X_1Y2_BUF dcc_out 1Y2_int VDD_3_3_V GND 25 2.8p OUTPUT_BUFFER
R_1Y2_PIN 1Y2_int 1Y2 10 ; Small series R to represent package/trace
C_1Y2_PIN 1Y2 GND 2.8p ; Pin capacitance

* 1Y3 Output
* Co = 2.8 pF, R_SERIES = 25 Ohm
X_1Y3_BUF dcc_out 1Y3_int VDD_3_3_V GND 25 2.8p OUTPUT_BUFFER
R_1Y3_PIN 1Y3_int 1Y3 10 ; Small series R to represent package/trace
C_1Y3_PIN 1Y3 GND 2.8p ; Pin capacitance

* --- Behavioral Jitter Model for Outputs ---
* Add a small random jitter to output signals to meet tc(jit_cc) spec.
* This is a simplified model. Real jitter is complex.
* For 70ps to 150ps (66-200MHz) and 200ps to 400ps (24-50MHz)
* We'll add a small random delay variation.
.param JITTER_MAG = 100p ; Average jitter magnitude in ps
.param JITTER_FREQ = 1M ; Frequency of jitter variation

B_JITTER_SOURCE jitter_ctrl GND V = { JITTER_MAG * sin(2*pi*JITTER_FREQ*time + V(CLKIN)*1e-9) }

* Apply jitter to the internal clock before output buffers
* This is a conceptual representation. In a real design, jitter comes from VCO noise.
* For this model, we'll assume the VCO already has some jitter and the buffers add minimal.
* The `tpd` spec (-150ps to 150ps) implies very low delay variation.
* The `tc(jit_cc)` spec is cycle-to-cycle jitter.

* The behavioral VCO already has a jitter source. The output buffers are assumed to be well-matched.
* The `tpd` and `tsk(o)` are primarily determined by buffer delays and matching.
* The `tc(jit_cc)` is dominated by the PLL's intrinsic jitter.

.ends CDCVF2505_Q1
