* TL431/TL432 Three-Terminal Adjustable Shunt Regulator
* Pinout: K (Cathode), A (Anode), REF (Reference)
.subckt TL431__TL432 K REF A

* --- Model Definitions ---
.model NMOS NMOS (LEVEL=1 VTO=0.7 KP=100u LAMBDA=0.02 TOX=100n GAMMA=0.5 PHI=0.6)
.model PMOS PMOS (LEVEL=1 VTO=-0.7 KP=40u LAMBDA=0.03 TOX=100n GAMMA=0.6 PHI=0.6)
.model NPN NPN (BF=100 VAF=50 IS=1e-14 CJE=1p CJC=2p RC=1 RE=0.1 RB=10 IKF=0.1)
.model PNP PNP (BF=50 VAF=30 IS=1e-14 CJE=2p CJC=3p RC=2 RE=0.2 RB=20 IKF=0.05)

* --- Internal Voltage Reference (Bandgap-like) ---
* Simplified bandgap reference for ~2.5V output with temperature compensation
* Vref_bandgap is the core reference voltage
* Vref_trim allows for initial tolerance adjustment (0.5%, 1%, 2%)
B_Vref_bandgap Vref_bandgap 0 V = {2.495 + V(Vref_trim_val)} ; Typical Vref = 2.495V

* --- Error Amplifier ---
* Input Differential Pair (PMOS)
M1 REF V_bias_diff_gate V_bias_diff_source V_bias_diff_source PMOS W=10u L=1u
M2 Vref_bandgap V_bias_diff_gate V_bias_diff_source V_bias_diff_source PMOS W=10u L=1u

* Current Mirror Load (NMOS)
M3 V_diff_out V_cm_gate 0 0 NMOS W=5u L=1u
M4 V_bias_diff_source V_cm_gate 0 0 NMOS W=5u L=1u

* Second Stage (Common Source with Active Load)
M5 V_amp_out V_diff_out V_bias_amp_source V_bias_amp_source PMOS W=20u L=1u
M6 V_amp_out V_cm_gate 0 0 NMOS W=10u L=1u

* Compensation Capacitor
Ccomp V_diff_out V_amp_out 50p

* --- Bias Circuitry ---
* Constant current source for differential pair
Ibias_diff V_bias_diff_source 0 DC 10uA

* Constant current source for second stage
Ibias_amp V_bias_amp_source 0 DC 20uA

* Gate bias for current mirror loads (M3, M4, M6)
R_cm_bias VDD V_cm_gate 100k
I_cm_bias 0 V_cm_gate DC 10uA ; Sets the gate voltage for the current mirror

* Gate bias for differential pair (M1, M2)
R_diff_gate VDD V_bias_diff_gate 100k
I_diff_gate 0 V_bias_diff_gate DC 5uA

* --- Output Stage ---
* NPN output transistor
Q1 K V_amp_out A NPN

* --- ESD Protection (Simplified) ---
* Diodes to clamp REF pin to K and A
D_ref_k REF K D_ESD
D_ref_a A REF D_ESD
.model D_ESD D (IS=1e-15 BV=40 IBV=1e-5)

* --- Vref Trim for Initial Tolerance ---
* This source allows setting the Vref offset for different grades.
* For typical operation, set Vref_trim_val to 0.
* For 0.5% tolerance: Vref_trim_val = 2.5V * 0.005 = 12.5mV
* For 1% tolerance: Vref_trim_val = 2.5V * 0.01 = 25mV
* For 2% tolerance: Vref_trim_val = 2.5V * 0.02 = 50mV
V_Vref_trim Vref_trim_val 0 DC 0V ; Set to 0V for typical, adjust for tolerance

* --- Power Supply for Internal Circuitry (Derived from K and A) ---
* The internal circuitry needs a supply. We'll assume a virtual VDD for the internal blocks
* that is derived from K, and a virtual GND that is A.
* This is a simplification, as the actual TL431 uses the K-A voltage as its supply.
* For the internal bias and amplifier, we need a stable supply.
* Let's create a virtual VDD and GND for the internal blocks.
* VDD_internal is derived from K, GND_internal is A.
* The internal bias currents and amplifier stages operate between these.
* For simplicity, we'll assume the internal VDD is K and internal GND is A for the bias.
* The PMOS sources are connected to a node that is effectively VDD for the internal circuit.
* The NMOS drains are connected to a node that is effectively GND for the internal circuit.
* Let's define VDD_internal as K and GND_internal as A for the internal bias.
* The current sources and resistors are connected to these.
* Re-evaluate the bias connections to reflect K-A supply.

* Re-architecting bias for K-A supply
* The internal circuitry operates from VKA.
* The PMOS sources will be connected to K.
* The NMOS sources will be connected to A.

* --- Re-architected Error Amplifier for K-A supply ---
* Input Differential Pair (PMOS)
M1_2 REF V_bias_diff_gate K K PMOS W=10u L=1u
M2_2 Vref_bandgap V_bias_diff_gate K K PMOS W=10u L=1u

* Current Mirror Load (NMOS)
M3_2 V_diff_out V_cm_gate A A NMOS W=5u L=1u
M4_2 V_bias_diff_source V_cm_gate A A NMOS W=5u L=1u

* Second Stage (Common Source with Active Load)
M5_2 V_amp_out V_diff_out K K PMOS W=20u L=1u
M6_2 V_amp_out V_cm_gate A A NMOS W=10u L=1u

* Compensation Capacitor
Ccomp_2 V_diff_out V_amp_out 50p

* --- Re-architected Bias Circuitry for K-A supply ---
* Constant current source for differential pair
Ibias_diff_2 K V_bias_diff_source DC 10uA

* Constant current source for second stage
Ibias_amp_2 K V_bias_amp_source DC 20uA

* Gate bias for current mirror loads (M3, M4, M6)
R_cm_bias_2 K V_cm_gate 100k
I_cm_bias_2 A V_cm_gate DC 10uA ; Sets the gate voltage for the current mirror

* Gate bias for differential pair (M1, M2)
R_diff_gate_2 K V_bias_diff_gate 100k
I_diff_gate_2 A V_bias_diff_gate DC 5uA

* --- Output Stage ---
* NPN output transistor
Q1_2 K V_amp_out A NPN

* --- Vref Trim for Initial Tolerance ---
V_Vref_trim_2 Vref_trim_val 0 DC 0V ; Set to 0V for typical, adjust for tolerance

.ends TL431__TL432
