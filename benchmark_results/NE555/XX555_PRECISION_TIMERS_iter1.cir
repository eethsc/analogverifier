.subckt XX555_PRECISION_TIMERS CONT DISCH GND NC OUT RESET THRES TRIG VCC

* --- Model Definitions ---
.model NMOS NMOS (LEVEL=1 VTO=1 KP=50u LAMBDA=0.05)
.model PMOS PMOS (LEVEL=1 VTO=-1 KP=25u LAMBDA=0.05)
.model QNPN NPN (IS=1e-14 BF=200 VAF=50 IKF=0.1 RB=10 RC=1 RE=0.1 CJE=1p CJC=1p TF=0.1n TR=1n VCE_SAT=0.1)
.model QPNP PNP (IS=1e-14 BF=100 VAF=40 IKF=0.05 RB=20 RC=2 RE=0.2 CJE=2p CJC=2p TF=0.2n TR=2n VCE_SAT=0.1)
.model DMOD D (IS=1e-14)

* --- Internal Voltage References (Voltage Divider) ---
* R1, R2, R3 form a voltage divider to create VCC/3 and 2*VCC/3 references.
* CONT pin is connected to the 2/3 VCC node.
R1 VCC node_2_3_VCC 10k
R2 node_2_3_VCC node_1_3_VCC 10k
R3 node_1_3_VCC GND 10k

* Connect CONT pin to the 2/3 VCC node
E_CONT_BUFFER CONT_INT CONT VALUE = {V(CONT)} ; Buffer CONT input to prevent loading the divider
R_CONT_BUFFER CONT_INT node_2_3_VCC 1m ; Small resistance to allow external override of 2/3 VCC

* --- Comparators ---
* Comparator 1 (Threshold Comparator): THRES vs. CONT (or 2/3 VCC)
* Output goes high when THRES > CONT
B_COMP_THRES comp_thres_out GND V = { (V(THRES) > V(CONT_INT)) ? V(VCC) : 0 }

* Comparator 2 (Trigger Comparator): TRIG vs. 1/3 VCC
* Output goes high when TRIG < 1/3 VCC
B_COMP_TRIG comp_trig_out GND V = { (V(TRIG) < V(node_1_3_VCC)) ? V(VCC) : 0 }

* --- SR Flip-Flop (NOR-based) ---
* Set input (S_ff) from Trigger Comparator (active high)
* Reset input (R_ff) from Threshold Comparator (active high) OR external RESET (active low)

* Invert RESET pin for active-high reset to flip-flop
M_RESET_INV_P reset_inv_out RESET VCC VCC PMOS W=20u L=1u
M_RESET_INV_N reset_inv_out RESET GND GND NMOS W=10u L=1u
R_RESET_PULLUP RESET VCC 100k ; Pull-up for RESET pin if left floating

* NOR Gate 1 (Q_ff_bar)
M_NOR1_P1 Q_ff_bar comp_trig_out VCC VCC PMOS W=20u L=1u
M_NOR1_P2 Q_ff_bar reset_ff_in VCC VCC PMOS W=20u L=1u
M_NOR1_N1 Q_ff_bar comp_trig_out node_nor1_n GND NMOS W=10u L=1u
M_NOR1_N2 node_nor1_n reset_ff_in GND GND NMOS W=10u L=1u

* NOR Gate 2 (Q_ff)
M_NOR2_P1 Q_ff Q_ff_bar VCC VCC PMOS W=20u L=1u
M_NOR2_P2 Q_ff reset_ff_in VCC VCC PMOS W=20u L=1u ; This is incorrect for cross-coupled NOR.
* Corrected NOR Gate 2 for cross-coupled SR FF:
* The second NOR gate's inputs are Q_ff_bar and R_ff.
M_NOR2_P1_corr Q_ff Q_ff_bar VCC VCC PMOS W=20u L=1u
M_NOR2_P2_corr Q_ff reset_ff_in VCC VCC PMOS W=20u L=2u ; R_ff input to Q_ff NOR
M_NOR2_N1_corr Q_ff Q_ff_bar node_nor2_n GND NMOS W=10u L=1u
M_NOR2_N2_corr node_nor2_n reset_ff_in GND GND NMOS W=10u L=1u

* Combine comparator reset and external reset
B_RESET_COMBINED reset_ff_in GND V = { (V(comp_thres_out) > V(VCC)/2) | (V(reset_inv_out) > V(VCC)/2) ? V(VCC) : 0 }

* --- Discharge Transistor ---
* Q_DISCH turns on when Q_ff is low (OUT is low)
* Need an inverter to drive Q_DISCH base from Q_ff
M_DISCH_INV_P disch_driver Q_ff VCC VCC PMOS W=20u L=1u
M_DISCH_INV_N disch_driver Q_ff GND GND NMOS W=10u L=1u

Q_DISCH DISCH disch_driver GND QNPN W=100u L=10u ; Sized for 8mA with low Vce_sat

* --- Output Buffer ---
* Push-pull stage to drive OUT pin.
* Q_ff (high) -> OUT high, Q_ff (low) -> OUT low.
* Driver for PNP (sourcing)
M_OUT_DRV_PNP_P out_drv_p Q_ff VCC VCC PMOS W=40u L=1u
M_OUT_DRV_PNP_N out_drv_p Q_ff GND GND NMOS W=20u L=1u

* Driver for NPN (sinking)
M_OUT_DRV_NPN_P out_drv_n Q_ff VCC VCC PMOS W=20u L=1u
M_OUT_DRV_NPN_N out_drv_n Q_ff GND GND NMOS W=40u L=1u

* Output Power Transistors (sized for 200mA)
Q_OUT_PNP VCC out_drv_p OUT QPNP W=500u L=10u ; Sourcing
Q_OUT_NPN OUT out_drv_n GND QNPN W=500u L=10u ; Sinking

* --- NC Pin ---
* No internal connection, simply connect to a dummy node or leave floating.
* For SPICE, it's good practice to connect it to a high-impedance node or GND if not used.
* Here, we'll just leave it as a terminal.

.ends XX555_PRECISION_TIMERS
