.subckt LM393B__LM2903B__LM193__LM293__LM393_AND_LM2903_DUAL_COMPARATORS 1OUT 1IN_NEG 1IN_POS GND 2IN_POS 2IN_NEG 2OUT VCC Thermal_Pad

; Connect Thermal_Pad to GND as specified
R_Thermal_Pad_GND Thermal_Pad GND 1m

; --- Global Bias Network (Shared by both comparators) ---
; This network generates a stable reference current for the current mirrors.
; Designed for low quiescent current (IQ) and wide supply range.
; Q10, R2, R3 form a VBE multiplier or a simple current source reference.
; Let's aim for a total IQ of ~400uA for both comparators at 5V.
; Each comparator will consume roughly 200uA.
; A reference current of ~50uA might be appropriate.

Q10 VCC bias_ref GND NPN_MODEL ; Reference transistor
R2 VCC bias_ref 100k          ; Sets current for Q10
R3 bias_ref GND 10k           ; Helps stabilize bias point

; --- Comparator 1 ---

; Input Stage: PNP Differential Pair with Current Mirror Load
; PNP inputs allow common-mode input down to GND.
; Q1, Q2: Input differential pair
; Q3: Current source for differential pair tail
; Q4, Q5: Current mirror load for differential pair
; R1: Emitter resistor for Q3 to set tail current

Q1 1IN_NEG 1IN_NEG_base 1IN_POS PNP_MODEL ; Input PNP, collector to 1IN_NEG_base for current mirror
Q2 1IN_POS 1IN_POS_base 1IN_POS PNP_MODEL ; Input PNP, collector to 1IN_POS_base for current mirror

; Current mirror for differential pair load (Q4, Q5)
; Q4: Diode-connected, sets current for Q5
; Q5: Mirrors current from Q4 to the output of the differential stage
Q4 1IN_NEG_base 1IN_NEG_base VCC PNP_MODEL ; Diode-connected PNP
Q5 1IN_POS_base 1IN_NEG_base VCC PNP_MODEL ; Current mirror load

; Tail current source for differential pair (Q3, R1)
; Q3: NPN current source
; R1: Emitter resistor to set current
Q3 1IN_POS GND bias_ref NPN_MODEL ; Tail current source for diff pair
R1 GND 1IN_POS 10k             ; Emitter resistor for Q3

; Second Stage: Common Emitter Amplifier
; Q6: NPN common emitter amplifier
; Q7: Active load for Q6 (current mirror)
; C1: Miller compensation capacitor for stability

Q6 1OUT_driver 1IN_POS_base GND NPN_MODEL ; Common emitter amplifier
Q7 VCC 1OUT_driver 1OUT_driver PNP_MODEL ; Active load for Q6 (diode-connected)
C1 1OUT_driver 1IN_POS_base 10p         ; Miller compensation

; Output Stage: Open Collector NPN
; Q8: Driver for output NPN
; Q9: Open collector output transistor

Q8 1OUT_driver_base 1OUT_driver GND NPN_MODEL ; Driver for output NPN
Q9 1OUT 1OUT_driver_base GND NPN_MODEL ; Open collector output transistor

; --- Comparator 2 ---
; Identical structure to Comparator 1

; Input Stage: PNP Differential Pair with Current Mirror Load
Q11 2IN_NEG 2IN_NEG_base 2IN_POS PNP_MODEL
Q12 2IN_POS 2IN_POS_base 2IN_POS PNP_MODEL

Q14 2IN_NEG_base 2IN_NEG_base VCC PNP_MODEL
Q15 2IN_POS_base 2IN_NEG_base VCC PNP_MODEL

Q13 2IN_POS GND bias_ref NPN_MODEL
R11 GND 2IN_POS 10k

; Second Stage: Common Emitter Amplifier
Q16 2OUT_driver 2IN_POS_base GND NPN_MODEL
Q17 VCC 2OUT_driver 2OUT_driver PNP_MODEL
C11 2OUT_driver 2IN_POS_base 10p

; Output Stage: Open Collector NPN
Q18 2OUT_driver_base 2OUT_driver GND NPN_MODEL
Q19 2OUT 2OUT_driver_base GND NPN_MODEL

; --- ESD Protection Diodes ---
; Diodes to VCC and GND on all input and output pins
; These are simplified models for ESD clamps.
; Real ESD structures are more complex but these serve the purpose for functional simulation.

; Comparator 1 Inputs
D1 VCC 1IN_NEG D_ESD
D2 1IN_NEG GND D_ESD
D3 VCC 1IN_POS D_ESD
D4 1IN_POS GND D_ESD

; Comparator 1 Output
D5 VCC 1OUT D_ESD
D6 1OUT GND D_ESD

; Comparator 2 Inputs
D7 VCC 2IN_NEG D_ESD
D8 2IN_NEG GND D_ESD
D9 VCC 2IN_POS D_ESD
D10 2IN_POS GND D_ESD

; Comparator 2 Output
D11 VCC 2OUT D_ESD
D12 2OUT GND D_ESD

; --- Transistor Models ---
; Parameters are chosen to represent typical bipolar transistors
; and to meet the specified performance characteristics.
; BF (Beta Forward) for high gain and low input bias current.
; IS (Saturation Current) for leakage and VBE.
; VAF (Forward Early Voltage) for high output impedance (gain).
; IKF (Forward Beta Roll-off) for high current operation.
; VCC up to 38V implies high breakdown voltages (BVCBO, BVCEO).

.model NPN_MODEL NPN ( Is=1e-14 Bf=200 Vaf=100 Ikf=0.1 Ise=1e-13 Ne=1.5
+ Br=5 Var=10 Ikr=0.01 Isc=1e-13 Nc=2
+ Rb=10 Rc=1 Re=0.5
+ Cje=5p Cjc=5p Tf=0.3n Tr=10n
+ Vceo=40 Vcbo=50 Veo=7
)

.model PNP_MODEL PNP ( Is=1e-14 Bf=150 Vaf=80 Ikf=0.05 Ise=1e-13 Ne=1.5
+ Br=3 Var=8 Ikr=0.005 Isc=1e-13 Nc=2
+ Rb=15 Rc=2 Re=1
+ Cje=8p Cjc=8p Tf=0.5n Tr=15n
+ Vceo=40 Vcbo=50 Veo=7
)

.model D_ESD D (Is=1e-15 Rs=1 Cjo=10p Bv=40 Ibv=1u)

.ends LM393B__LM2903B__LM193__LM293__LM393_AND_LM2903_DUAL_COMPARATORS
