.include "LM386_iter2.cir"
.options gmin=1e-12 cshunt=1e-15

.end
