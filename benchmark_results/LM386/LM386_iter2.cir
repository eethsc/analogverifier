.subckt LM386 GAIN1 IN_INV IN_NONINV GND VOUT VS BYPASS GAIN8

* --- BJT Models ---
.model QNPN NPN(Is=1e-14 Bf=100 Vaf=100 Ikf=0.1 Ise=1e-14 Ne=1.5 Rb=10 Rc=1 Re=0.1 Cjc=2p Cje=3p Tf=0.3n Tr=6n Vceo=30 Icrating=0.5)
.model QPNP PNP(Is=1e-14 Bf=50 Vaf=50 Ikf=0.05 Ise=1e-14 Ne=1.5 Rb=20 Rc=2 Re=0.2 Cjc=3p Cje=4p Tf=0.6n Tr=12n Vceo=30 Icrating=0.2)

* --- Resistor and Capacitor Models (Generic) ---
.model RES R
.model CAP C

* --- Power Supply and Ground ---
V_VS VS GND DC 'VS_VAL' ; Supply voltage, will be set by testbench
V_GND GND 0 DC 0

* --- Bias Network ---
* Generates a stable bias reference voltage
R_bias_div1 VS bias_ref_node 10k
R_bias_div2 bias_ref_node GND 10k
Q_bias_ref_buffer bias_ref_node bias_ref_node bias_ref QNPN ; Buffer for bias_ref
R_bias_ref_emitter bias_ref GND 1k

* Current mirror for tail current and other bias currents
Q_bias_ref_diode VS bias_ref bias_ref QPNP ; Diode connected for current mirror reference
Q_bias_current_source VS bias_ref tail_current_node QPNP ; Current source for differential pair
R_tail_current_set tail_current_node GND 2k ; Sets the tail current

* --- Input Stage (Differential Amplifier) ---
Q1 diff_out_p IN_NONINV emitter_node QNPN ; Non-inverting input
Q2 diff_out_n IN_INV emitter_node QNPN ; Inverting input
I_tail emitter_node GND DC 100uA ; Tail current source for differential pair (Adjust for IBIAS)

* Current mirror load for differential pair (converts differential to single-ended)
Q3 VS diff_out_p collector_load_p QPNP
Q4 VS diff_out_n collector_load_n QPNP
Q7 collector_load_p collector_load_p diff_out QNPN ; Diode-connected
Q8 collector_load_n collector_load_p diff_out QNPN

* --- Gain Stage ---
Q9 gain_stage_out diff_out gain_stage_emitter QNPN ; Common emitter amplifier
R_gain_stage_emitter gain_stage_emitter GND 500 ; Emitter degeneration for stability
Q10 VS gain_stage_out gain_stage_load QPNP ; Current source load for gain stage
Q11 VS gain_stage_load gain_stage_load QPNP ; Diode connected for current mirror reference

* --- Gain Control (Pins 1 and 8) ---
* Internal feedback for gain of 20
R_gain_internal1 gain_stage_out GAIN1 10k
R_gain_internal2 GAIN1 GAIN8 1.2k ; This resistor sets the gain with R_gain_internal1
R_gain_internal3 GAIN8 GND 10k

* The GAIN pins (1 and 8) are connected to the feedback network.
* When open, the internal resistors set the gain.
* When a capacitor is added between GAIN1 and GAIN8, it bypasses R_gain_internal2 for AC, increasing gain.

* --- Output Stage (Class AB) ---
* Vbe multiplier for biasing Class AB output stage
Q14 V_vbe_mult_out V_vbe_mult_in V_vbe_mult_in QNPN
R_vbe_mult1 VS V_vbe_mult_in 10k
R_vbe_mult2 V_vbe_mult_in GND 10k
R_vbe_mult3 V_vbe_mult_out GND 10k ; To set quiescent current

* Driver for output stage
Q_driver_n V_vbe_mult_out gain_stage_out driver_n_emitter QNPN
R_driver_n_emitter driver_n_emitter GND 100

Q_driver_p V_vbe_mult_out gain_stage_out driver_p_emitter QPNP
R_driver_p_emitter driver_p_emitter VS 100

* Output transistors
Q12 VOUT V_vbe_mult_out VS QNPN ; NPN output transistor
Q13 VOUT V_vbe_mult_out GND QPNP ; PNP output transistor

* Output series resistor for stability
R_out_series VOUT_internal VOUT 10

* --- Frequency Compensation ---
C_comp gain_stage_out diff_out 100p ; Compensation capacitor for stability and bandwidth

* --- Bypass Pin (Pin 7) ---
* Connects to the common emitter of the input differential pair for PSRR improvement
C_bypass BYPASS GND 10u ; External bypass capacitor (typically 10uF)

* --- Output Bias to VS/2 ---
* The overall feedback and biasing should naturally set VOUT to VS/2.
* The input stage is ground referenced. The output stage is biased to center the output swing.

.ends LM386
