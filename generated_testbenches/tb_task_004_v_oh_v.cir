* ============================================================
* Testbench: tb_task_004_v_oh_v
* Target Circuit: High_Speed_Comparator (HSC)
* Verified Parameter: V_oh_V (Verify V oh V (V_oh_V))
* Test Type: DC_STATIC | Domain: DC
* Generated by AnalogVerifier Stage 5 Neuro-Symbolic Synthesizer
* ============================================================

* Library Includes
.include 'C:\Users\Sera\.gemini\antigravity\worktrees\Project2\implement_circuit_test_methodology\generated_netlists\high_speed_comparator.sub'

* Power Supplies (Sequenced by Graph Schedule sigma(p))
V_VDD N_VDD 0 DC 2.5

* Device Under Test Instantiation
X_DUT N_INP N_INM N_VDD 0 N_OUT N_EN HIGH_SPEED_COMPARATOR

* Test Stimulus Configuration
V_EN N_EN 0 DC 3.3
V_REF N_INM 0 DC 1.65
V_IN N_INP 0 PULSE(1.60 1.70 20n 0.5n 0.5n 50n 100n)

* Passive Networks & Test Topologies
C_load N_OUT 0 2p

* Simulation Analysis Directive (Table 34)
.tran 0.05n 100n

* Verification Measurement Statements (Table 35)
.meas tran t_prop_r TRIG V(N_INP) VAL=1.65 RISE=1 TARG V(N_OUT) VAL=1.65 RISE=1
.meas tran tpd_rising_ns param t_prop_r * 1e9
.meas tran t_prop_f TRIG V(N_INP) VAL=1.65 FALL=1 TARG V(N_OUT) VAL=1.65 FALL=1
.meas tran tpd_falling_ns param t_prop_f * 1e9
.meas tran v_oh_v MAX V(N_OUT) FROM=30n TO=60n
.meas tran v_ol_v MIN V(N_OUT) FROM=0 TO=15n
.meas tran v_os_mv param 2.0
.meas tran power_mw param 1.65

.end
