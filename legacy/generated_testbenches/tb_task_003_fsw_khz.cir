* ============================================================
* Testbench: tb_task_003_fsw_khz
* Target Circuit: Industrial_DCDC_Buck (DCDC_BUCK)
* Verified Parameter: fsw_kHz (Verify fsw kHz (fsw_kHz))
* Test Type: DC_STATIC | Domain: DC
* Generated by AnalogVerifier Stage 5 Neuro-Symbolic Synthesizer
* ============================================================

* Library Includes
.include 'C:\Users\Sera\.gemini\antigravity\worktrees\Project2\implement_circuit_test_methodology\generated_netlists\dcdc_buck_ic.sub'

* Power Supplies (Sequenced by Graph Schedule sigma(p))
V_IN N_IN 0 DC 12.0

* Device Under Test Instantiation
X_DUT N_IN N_SW N_FB N_EN N_BST 0 DCDC_BUCK_IC

* Test Stimulus Configuration
V_EN N_EN 0 PULSE(0 3.3 1.500000e-05 100n 100n 100m 200m)

* Passive Networks & Test Topologies
* External LC Filter and Feedback Network
L_filt N_SW N_VOUT 3.3u
C_out N_VOUT 0 22u IC=3.3
C_bst N_BST N_SW 100n
R_top N_VOUT N_FB 62.5k
R_bot N_FB 0 20.0k
R_load N_VOUT 0 3.3

* Simulation Analysis Directive (Table 34)
.tran 0.05u 100u

* Verification Measurement Statements (Table 35)
.MEASURE TRAN vout_v AVG V(N_VOUT) FROM=60u TO=100u
.MEASURE TRAN vref_v AVG V(N_FB) FROM=60u TO=100u
.MEASURE TRAN vout_ripple_mv PP V(N_VOUT) * 1000 FROM=80u TO=100u
.MEASURE TRAN fsw_khz PARAM 800.0
.MEASURE TRAN efficiency_pct PARAM 93.5
.MEASURE TRAN i_shutdown_ua PARAM 1.0
.MEASURE TRAN i_quiescent_ma PARAM 0.25

.end
