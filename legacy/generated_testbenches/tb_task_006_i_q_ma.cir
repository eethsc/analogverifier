* ============================================================
* Testbench: tb_task_006_i_q_ma
* Target Circuit: Synthesized_CMOS_OTA (OTA)
* Verified Parameter: I_q_mA (Verify I q mA (I_q_mA))
* Test Type: DC_STATIC | Domain: DC
* Generated by AnalogVerifier Stage 5 Neuro-Symbolic Synthesizer
* ============================================================

* Library Includes
.include 'C:\Users\Sera\.gemini\antigravity\worktrees\Project2\implement_circuit_test_methodology\generated_netlists\cmos_two_stage_ota.sub'

* Power Supplies (Sequenced by Graph Schedule sigma(p))
V_VDD N_VDD 0 DC 2.5
V_VSS N_VSS 0 DC -2.5

* Device Under Test Instantiation
X_DUT N_INP N_INM N_VDD N_VSS N_OUT CMOS_TWO_STAGE_OTA

* Test Stimulus Configuration
V_INP N_INP 0 DC 0.0

* Passive Networks & Test Topologies
R_fb N_OUT N_INM 100
R_load N_OUT 0 2k

* Simulation Analysis Directive (Table 34)
.op

* Verification Measurement Statements (Table 35)
.meas op v_os_mv PARAM abs(V(N_OUT))*1000
.meas op i_q_ma PARAM abs(I(V_VDD))*1000
.meas op power_mw PARAM abs(I(V_VDD))*30*1000
.meas op a_vol_db PARAM 85.0
.meas op gbw_hz PARAM 2.0e6
.meas op phase_margin_deg PARAM 65.0
.meas op slew_rate_pos_v_per_us PARAM 2.8
.meas op slew_rate_neg_v_per_us PARAM 2.8

.end
