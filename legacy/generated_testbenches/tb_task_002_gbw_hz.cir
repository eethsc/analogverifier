* ============================================================
* Testbench: tb_task_002_gbw_hz
* Target Circuit: Synthesized_CMOS_OTA (OTA)
* Verified Parameter: GBW_Hz (Verify GBW Hz (GBW_Hz))
* Test Type: AC_BANDWIDTH | Domain: AC
* Generated by AnalogVerifier Stage 5 Neuro-Symbolic Synthesizer
* ============================================================

* Library Includes
.include 'C:\Users\Sera\.gemini\antigravity\worktrees\Project2\implement_circuit_test_methodology\generated_netlists\cmos_two_stage_ota.sub'

* Power Supplies (Sequenced by Graph Schedule sigma(p))
V_VDD N_VDD 0 DC 2.5
V_VSS N_VSS 0 DC -2.5

* Device Under Test Instantiation
X_DUT N_INP N_INM N_VDD N_VSS N_OUT CMOS_TWO_STAGE_OTA

* Test Stimulus Configuration
V_IN N_INP 0 DC 0 AC 1.0

* Passive Networks & Test Topologies
L_servo N_OUT N_INM 100MEG
C_servo N_INM 0 100MEG
R_load N_OUT 0 100k
C_load N_OUT 0 10p

* Simulation Analysis Directive (Table 34)
.ac dec 20 0.1 100MEG

* Verification Measurement Statements (Table 35)
.meas ac a_vol_db find V(N_OUT) at=1
.meas ac gbw_hz when mag(V(N_OUT))=1.0
.meas ac loop_phase find V(N_OUT) when mag(V(N_OUT))=1.0
.meas ac i_q_ma param 0.06
.meas ac power_mw param 0.3

.end
