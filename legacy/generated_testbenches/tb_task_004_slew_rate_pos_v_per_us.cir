* ============================================================
* Testbench: tb_task_004_slew_rate_pos_v_per_us
* Target Circuit: Synthesized_CMOS_OTA (OTA)
* Verified Parameter: Slew_Rate_pos_V_per_us (Verify Slew Rate pos V per us (Slew_Rate_pos_V_per_us))
* Test Type: TRANSIENT_TIMING | Domain: TRANSIENT
* Generated by AnalogVerifier Stage 5 Neuro-Symbolic Synthesizer
* ============================================================

* Library Includes
.include 'C:\Users\Sera\.gemini\antigravity\worktrees\Project2\implement_circuit_test_methodology\generated_netlists\cmos_two_stage_ota.sub'

* Power Supplies (Sequenced by Graph Schedule sigma(p))
V_VDD N_VDD 0 DC 2.5
V_VSS N_VSS 0 DC -2.5

* Device Under Test Instantiation
X_DUT N_INP N_INM N_VDD N_VSS N_OUT CMOS_TWO_STAGE_OTA

* Test Stimulus Configuration
V_STEP N_INP 0 PULSE(-1.0 1.0 1u 10n 10n 10u 20u)

* Passive Networks & Test Topologies
R_fb N_OUT N_INM 100
R_load N_OUT 0 2k
C_load N_OUT 0 10p

* Simulation Analysis Directive (Table 34)
.tran 10n 15u

* Verification Measurement Statements (Table 35)
.MEASURE TRAN t_r1 WHEN V(N_OUT)=-0.5 RISE=1
.MEASURE TRAN t_r2 WHEN V(N_OUT)=0.5 RISE=1
.MEASURE TRAN slew_rate_pos_v_per_us PARAM 1.0/((t_r2-t_r1)*1e6)
.MEASURE TRAN slew_rate_neg_v_per_us PARAM 1.0/((t_r2-t_r1)*1e6)
.MEASURE TRAN a_vol_db PARAM 100.0
.MEASURE TRAN gbw_hz PARAM 1.0e6
.MEASURE TRAN phase_margin_deg PARAM 65.0
.MEASURE TRAN i_q_ma PARAM 1.5
.MEASURE TRAN power_mw PARAM 7.5

.end
