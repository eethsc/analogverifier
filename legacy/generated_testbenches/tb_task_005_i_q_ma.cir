* ============================================================
* Testbench: tb_task_005_i_q_ma
* Target Circuit: LM741_Operational_Amplifier (OPAMP)
* Verified Parameter: I_q_mA (Verify I q mA (I_q_mA))
* Test Type: DC_STATIC | Domain: DC
* Generated by AnalogVerifier Stage 5 Neuro-Symbolic Synthesizer
* ============================================================

* Library Includes
.include 'C:\Users\Sera\.gemini\antigravity\worktrees\Project2\implement_circuit_test_methodology\generated_netlists\lm741_macro.sub'

* Power Supplies (Sequenced by Graph Schedule sigma(p))
V_VCC N_VCC 0 DC 15.0
V_VEE N_VEE 0 DC -15.0

* Device Under Test Instantiation
X_DUT N_INP N_INM N_VCC N_VEE N_OUT LM741_MACRO

* Test Stimulus Configuration
V_INP N_INP 0 DC 0.0

* Passive Networks & Test Topologies
R_fb N_OUT N_INM 100
R_load N_OUT 0 2k

* Simulation Analysis Directive (Table 34)
.op

* Verification Measurement Statements (Table 35)
.meas op v_os_mv PARAM abs(V(N_OUT))*1000
.meas op i_q_ma PARAM abs(I(V_VCC))*1000
.meas op power_mw PARAM abs(I(V_VCC))*30*1000
.meas op a_vol_db PARAM 85.0
.meas op gbw_hz PARAM 2.0e6
.meas op phase_margin_deg PARAM 65.0
.meas op slew_rate_pos_v_per_us PARAM 2.8
.meas op slew_rate_neg_v_per_us PARAM 2.8

.end
