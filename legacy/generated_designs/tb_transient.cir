.include "generated_designs/TLC2932A_iter1.cir"
.options gmin=1e-12 cshunt=1e-15
* LTspice Testbench for TLC2932A Lock Frequency Verification

.include "TLC2932A_iter1.cir"

* Power Supplies and Grounds
V_LOGIC_VDD LOGIC_VDD 0 PWL(0s 0V 10ns 3V)
V_VCO_VDD VCO_VDD 0 PWL(0s 0V 10ns 3V)
VGND_LOGIC LOGIC_GND 0 0
VGND_VCO VCO_GND 0 0

* Input Stimuli - Following PDG Activation Schedule
* RBIAS: 10.00 us
V_RBIAS RBIAS 0 PWL(0us 0V 9.99us 0V 10.00us 1.2V) ; Assuming a typical RBIAS voltage, adjust if needed

* SELECT, TEST, PFD_INHIBIT, VCO_INHIBIT, VCO_IN: 15.00 us
V_SELECT SELECT 0 PWL(0us 0V 14.99us 0V 15.00us 3V) ; Assuming active high, adjust if needed
V_TEST TEST 0 PWL(0us 0V 14.99us 0V 15.00us 0V) ; Assuming test mode off, adjust if needed
V_PFD_INHIBIT PFD_INHIBIT 0 PWL(0us 0V 14.99us 0V 15.00us 0V) ; PFD enabled
V_VCO_INHIBIT VCO_INHIBIT 0 PWL(0us 0V 14.99us 0V 15.00us 0V) ; VCO enabled
V_VCO_IN VCO_IN 0 PWL(0us 0V 14.99us 0V 15.00us 1.5V) ; Assuming a DC voltage for VCO control, adjust if needed

* FIN_A, FIN_B: 17.00 us
* For lock frequency measurement, we need to sweep FIN_A/FIN_B to find the lock range.
* We'll set FIN_A to a fixed frequency and sweep VCO_IN to find the lock point.
* Or, we can sweep FIN_A and observe PFD_OUT for lock.
* Let's assume FIN_A is the reference frequency input.
V_FIN_A FIN_A 0 PULSE(0V 3V 17.00us 1ns 1ns 25ns 50ns) ; Example 10MHz input (50ns period)
V_FIN_B FIN_B 0 PWL(0us 0V 16.99us 0V 17.00us 0V) ; Assuming FIN_B is not used or tied low for this test

* VCO_OUT, PFD_OUT: 18.00 us (These are outputs, no stimulus needed)

* DUT Instantiation
XDUT LOGIC_VDD SELECT VCO_OUT FIN_A FIN_B PFD_OUT LOGIC_GND TEST PFD_INHIBIT VCO_INHIBIT VCO_GND VCO_IN RBIAS VCO_VDD TLC2932A

* Simulation Command
.tran 0.5n 300n

* Measurement Directives for 'Lock frequency'
* Conditions: VDD = 3 V
* To measure lock frequency, we need to sweep the input frequency (FIN_A) and observe PFD_OUT.
* When locked, PFD_OUT should be a stable DC voltage (or very low frequency ripple).
* This requires multiple simulations or a more complex setup.
* For a single `.tran` run, we can set FIN_A to a specific frequency and check if it locks.
* Let's assume we are testing for a 20MHz lock frequency at VDD=3V.
* We need to adjust V_FIN_A to sweep frequencies or run multiple simulations.
* For this example, we'll set FIN_A to a frequency within the expected lock range and check for lock.

* Let's set FIN_A to 20MHz (period = 50ns) for VDD=3V test.
* We need to ensure the VCO can reach this frequency. VCO_IN will control the VCO frequency.
* For lock, PFD_OUT should settle to a DC value. We can check the ripple on PFD_OUT.
* A more robust test would involve sweeping FIN_A and checking PFD_OUT for a stable state.
* For a single `.tran` run, we'll assume a specific FIN_A and check for lock.

* Let's assume FIN_A is the reference frequency and VCO_OUT is the output frequency.
* We need the frequency of VCO_OUT when the loop is locked.
* The lock condition is typically indicated by PFD_OUT settling to a stable DC voltage.
* We will set FIN_A to a frequency and observe VCO_OUT.

* Test 1: VDD = 3V, FIN_A = 20MHz (within 13-32MHz range)
* Adjust V_LOGIC_VDD and V_VCO_VDD to 3V.
.param VDD_VAL = 3V
; Sanitized duplicate parallel voltage source short: V_LOGIC_VDD_2 LOGIC_VDD 0 PWL(0s 0V 10ns {VDD_VAL})
; Sanitized duplicate parallel voltage source short: V_VCO_VDD_2 VCO_VDD 0 PWL(0s 0V 10ns {VDD_VAL})
; Sanitized duplicate parallel voltage source short: V_FIN_A_2 FIN_A 0 PULSE(0V {VDD_VAL} 17.00us 1ns 1ns 24.9ns 49.9ns) ; ~20.04 MHz (1/49.9ns)

* Measure VCO_OUT frequency after settling (e.g., after 200ns)
.meas tran t_vco1 when V(VCO_OUT)={VDD_VAL/2} rise=10
.meas tran t_vco2 when V(VCO_OUT)={VDD_VAL/2} rise=11
.meas tran lock_freq_3V param 1/(t_vco2-t_vco1)

* Test 2: VDD = 3.3V, FIN_A = 25MHz (within 13-35MHz range)
* This requires a separate simulation run or parameter sweep.
* For this single deck, we'll demonstrate one condition.
* To test other VDDs, you would change VDD_VAL and rerun.

* Test 3: VDD = 5V, FIN_A = 40MHz (within 15-55MHz range)
* Similar to above, requires changing VDD_VAL and FIN_A frequency.

* To verify lock, one would typically look at PFD_OUT.
* If PFD_OUT is stable (e.g., low ripple around a DC value), the loop is locked.
* We can measure the peak-to-peak ripple on PFD_OUT.
.meas tran pfd_out_max MAX V(PFD_OUT) from=200n to=300n
.meas tran pfd_out_min MIN V(PFD_OUT) from=200n to=300n
.meas tran pfd_ripple param pfd_out_max - pfd_out_min

.end
