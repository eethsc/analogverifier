.options gmin=1e-12 cshunt=1e-15
* LTspice Testbench for TLC2932A Verification

.include "TLC2932A_iter1.cir"

* Voltage Sources for Power and Ground
V_LOGIC_VDD LOGIC_VDD 0 PWL(0us 0V 0.001us 0V 0.001001us 5V) ; Example VDD, will be varied for specs
V_LOGIC_GND LOGIC_GND 0 0V
V_VCO_GND VCO_GND 0 0V
V_VCO_VDD VCO_VDD 0 PWL(0us 0V 0.001us 0V 0.001001us 5V) ; Example VDD, will be varied for specs

* Input Stimulus - Following PDG Activation Schedule
* RBIAS
R_RBIAS RBIAS VCO_GND 3.3k ; Example value, will be varied for specs

* SELECT, TEST, PFD_INHIBIT, VCO_INHIBIT, VCO_IN
V_SELECT SELECT 0 PWL(0us 0V 14.99us 0V 15us 5V) ; Example high, will be varied
V_TEST TEST 0 PWL(0us 0V 14.99us 0V 15us 0V) ; Example low, will be varied
V_PFD_INHIBIT PFD_INHIBIT 0 PWL(0us 0V 14.99us 0V 15us 0V) ; Example low, will be varied
V_VCO_INHIBIT VCO_INHIBIT 0 PWL(0us 0V 14.99us 0V 15us 0V) ; Example low, will be varied
V_VCO_IN VCO_IN 0 PWL(0us 0V 14.99us 0V 15us 2.5V) ; Example 1/2 VDD, will be varied

* FIN_A, FIN_B
V_FIN_A FIN_A 0 PWL(0us 0V 16.99us 0V 17us 0V) ; Example low, will be varied
V_FIN_B FIN_B 0 PWL(0us 0V 16.99us 0V 17us 0V) ; Example low, will be varied

* Output Loads (VCO_OUT, PFD_OUT)
C_VCO_OUT VCO_OUT 0 15p ; Load for VCO_OUT
R_PFD_OUT PFD_OUT 0 10k ; Example load for PFD_OUT

* DUT Instance
XDUT LOGIC_VDD SELECT VCO_OUT FIN_A FIN_B PFD_OUT LOGIC_GND TEST PFD_INHIBIT VCO_INHIBIT VCO_GND VCO_IN RBIAS VCO_VDD TLC2932A

* Simulation Commands
.tran 0 100us 0 0.1us startup

* Measurement Directives

* VDD: Min=None, Typ=None, Max=7.0 V | Desc:  | Conditions: absolute maximum ratings
.meas tran VDD_abs_max_test PARAM 7.0

* VIN: Min=-0.5, Typ=None, Max=None V | Desc:  | Conditions: absolute maximum ratings, VDD + 0.5V
* This requires specific input voltage tests, not a simple measurement.
* For now, we'll assume inputs are within range.

* IIN: Min=-20.0, Typ=None, Max=20.0 mA | Desc:  | Conditions: absolute maximum ratings
* IO: Min=-20.0, Typ=None, Max=20.0 mA | Desc:  | Conditions: absolute maximum ratings
* These require specific current injection/sourcing tests.

* TA: Min=-20.0, Typ=None, Max=75.0 °C | Desc:  | Conditions: absolute maximum ratings
* Temperature is set by .temp, not measured directly.
.temp 25

* VDD: Min=2.85, Typ=3.0, Max=3.15 V | Desc:  | Conditions: VDD = 3 V
* This requires setting V_LOGIC_VDD and V_VCO_VDD to 3V and checking operation.
* For now, we'll measure the supply voltage.
.meas tran VDD_3V_min_test PARAM 2.85
.meas tran VDD_3V_max_test PARAM 3.15

* VDD: Min=3.135, Typ=3.3, Max=3.465 V | Desc:  | Conditions: VDD = 3.3 V
.meas tran VDD_3_3V_min_test PARAM 3.135
.meas tran VDD_3_3V_max_test PARAM 3.465

* VDD: Min=4.75, Typ=5.0, Max=5.25 V | Desc:  | Conditions: VDD = 5 V
.meas tran VDD_5V_min_test PARAM 4.75
.meas tran VDD_5V_max_test PARAM 5.25

* VIN: Min=0.0, Typ=None, Max=None V | Desc:  | Conditions: inputs except VCO IN, max VDD
* This implies inputs should not go below 0V.

* IO: Min=0.0, Typ=None, Max=2.0 mA | Desc:  | Conditions: each output
* This requires specific output loading tests.

* VCO IN: Min=0.9, Typ=None, Max=None V | Desc:  | Conditions: max VDD
* This implies VCO_IN should be >= 0.9V.

* Bias Resistor: Min=2.2, Typ=None, Max=5.1 kΩ | Desc:  | Conditions: VDD = 3 V
* Bias Resistor: Min=2.2, Typ=None, Max=5.1 kΩ | Desc:  | Conditions: VDD = 3.3 V
* Bias Resistor: Min=2.2, Typ=None, Max=5.1 kΩ | Desc:  | Conditions: VDD = 5 V
* These are design constraints, not directly measured from the subcircuit.
* We set R_RBIAS to 3.3k for typical operation.

* VOH: Min=2.4, Typ=None, Max=None V | Desc:  | Conditions: IOH = –2 mA
* This requires specific output loading to sink 2mA.
* Example for PFD_OUT (assuming it's an output that can source current)
* To measure VOH, we'd need to apply a current load.
* For now, we'll just measure the output voltage under a light load.
.meas tran VOH_PFD_OUT_light AVG V(PFD_OUT) from=20us to=90us

* VOL: Min=None, Typ=None, Max=0.3 V | Desc:  | Conditions: IOL = 2 mA
* This requires specific output loading to source 2mA.
* Example for PFD_OUT (assuming it's an output that can sink current)
* To measure VOL, we'd need to apply a current load.
.meas tran VOL_PFD_OUT_light AVG V(PFD_OUT) from=20us to=90us

* VTH: Min=0.9, Typ=1.5, Max=2.1 V | Desc:  | Conditions: None
* This requires sweeping an input voltage and finding the switching threshold.
* Not directly measurable with a single transient run.

* II: Min=-1.0, Typ=None, Max=1.0 µA | Desc:  | Conditions: VI = VDD or GND
* This requires measuring input currents under specific input voltage conditions.
.meas tran I_FIN_A_VDD AVG I(V_FIN_A) from=20us to=90us ; Assuming FIN_A is at VDD
.meas tran I_FIN_A_GND AVG I(V_FIN_A) from=20us to=90us ; Assuming FIN_A is at GND

* ZI(VCO IN): Min=10.0, Typ=None, Max=None MΩ | Desc:  | Conditions: VCO IN = 1/2 VDD
* This requires applying a small signal to VCO_IN and measuring current.
* For now, we'll measure the DC current into VCO_IN.
.meas tran I_VCO_IN_DC AVG I(V_VCO_IN) from=20us to=90us
.meas tran ZI_VCO_IN_est PARAM (V(VCO_IN)/I_VCO_IN_DC)

* IDD(INH): Min=None, Typ=0.35, Max=1.0 µA | Desc:  | Conditions: VCO INHIBIT = high, PFD is inhibited
* Set V_VCO_INHIBIT to high (e.g., 5V)
* Set V_PFD_INHIBIT to high (e.g., 5V)
* Measure total supply current.
.meas tran IDD_INH_AVG AVG -I(V_LOGIC_VDD) -I(V_VCO_VDD) from=20us to=90us

* IDD(VCO): Min=None, Typ=8.4, Max=17.0 mA | Desc:  | Conditions: VCO IN = 1/2 VDD, RBIAS = 3.3 kΩ, VCOOUT = 15-pF Load, VCO INHIBIT = GND, and PFD INHIBIT = GND
* Set V_VCO_IN to 1/2 VDD (e.g., 2.5V for 5V VDD)
* Set R_RBIAS to 3.3k
* Set C_VCO_OUT to 15pF
* Set V_VCO_INHIBIT to GND
* Set V_PFD_INHIBIT to GND
* Measure total supply current.
.meas tran IDD_VCO_AVG AVG -I(V_LOGIC_VDD) -I(V_VCO_VDD) from=20us to=90us

.end
