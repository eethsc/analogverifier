.subckt CDCVF2505_Q1 CLKIN 1Y1 1Y0 GND 1Y2 VDD_3_3_V 1Y3 CLKOUT

* --- Global Parameters ---
.param VDD_TYP = 3.3V
.param TEMP_TYP = 27

* --- Device Models (Generic CMOS 0.18um process parameters for 3.3V operation) ---
.model NMOS NMOS (LEVEL=1 VTO=0.5 KP=300u GAMMA=0.4 PHI=0.7 LAMBDA=0.05
+ TOX=4e-9 UO=400 NSUB=1e17 PB=0.8 CJ=500u CJSW=300p MJ=0.5 MJSW=0.3)
.model PMOS PMOS (LEVEL=1 VTO=-0.5 KP=100u GAMMA=0.5 PHI=0.7 LAMBDA=0.06
+ TOX=4e-9 UO=150 NSUB=1e17 PB=0.8 CJ=600u CJSW=350p MJ=0.5 MJSW=0.3)
.model D_ESD D (IS=1e-15 N=1.0 RS=10 CJO=1p TT=1n BV=50)

* --- ESD Protection Diodes (Simplified) ---
D_CLKIN_P CLKIN VDD_3_3_V D_ESD
D_CLKIN_N GND CLKIN D_ESD

D_1Y1_P 1Y1 VDD_3_3_V D_ESD
D_1Y1_N GND 1Y1 D_ESD

D_1Y0_P 1Y0 VDD_3_3_V D_ESD
D_1Y0_N GND 1Y0 D_ESD

D_1Y2_P 1Y2 VDD_3_3_V D_ESD
D_1Y2_N GND 1Y2 D_ESD

D_1Y3_P 1Y3 VDD_3_3_V D_ESD
D_1Y3_N GND 1Y3 D_ESD

D_CLKOUT_P CLKOUT VDD_3_3_V D_ESD
D_CLKOUT_N GND CLKOUT D_ESD

* --- Input Buffer (Schmitt Trigger) ---
* A simple behavioral Schmitt trigger for noise immunity and clean transitions.
* Thresholds: VIL = 0.3 * VDD_TYP, VIH = 0.7 * VDD_TYP
.param VIL_TH = '0.3 * VDD_TYP'
.param VIH_TH = '0.7 * VDD_TYP'

B_SCHMITT_OUT CLKIN_BUF_OUT GND V = { V(CLKIN) > VIH_TH ? VDD_TYP : (V(CLKIN) < VIL_TH ? 0 : V(CLKIN_BUF_OUT)) }

* Input Capacitance (Ci = 4.2 pF)
C_CLKIN_IN CLKIN GND 4.2p

* --- Power-Down Detection (Behavioral) ---
* Detects if CLKIN is stable (no transitions) for a period, then asserts PD_EN_N (active low).
* If CLKIN is active, PD_EN_N is high.
* Simplified model: If CLKIN has no transitions for 100ns, assume power-down.
* This is a very simplified model. A real power-down would involve more complex edge detection and timers.
B_CLKIN_EDGE CLKIN_EDGE GND V = { ddt(V(CLKIN)) }
R_PD_TIMER_R PD_TIMER_NODE GND 100k
C_PD_TIMER_C PD_TIMER_NODE GND 100p
B_PD_TIMER_CHARGE PD_TIMER_NODE GND I = { (abs(V(CLKIN_EDGE)) > 0.1) ? 10u : 0 } ; Charge if edge detected
B_PD_EN_N PD_EN_N GND V = { V(PD_TIMER_NODE) < 0.5 ? 0 : VDD_TYP } ; Active low power down enable

* --- PLL Core (Behavioral Model for PFD, CP, LF, VCO) ---
* This behavioral model aims to capture the essential PLL functionality:
* 1. Phase/Frequency detection
* 2. Loop filter action
* 3. Voltage controlled oscillation
* 4. Lock time (stabilization time)
* 5. Duty cycle correction

* PFD and Charge Pump (Simplified Behavioral)
* Generates a control voltage (V_CTRL) based on phase difference.
* V_CTRL range: 0 to VDD_TYP
B_PFD_CP V_CTRL GND V = { V(V_CTRL) + ( (V(CLKIN_BUF_OUT) > VDD_TYP/2 & V(CLKIN_BUF_OUT, CLKIN_BUF_OUT_DLY) < VDD_TYP/2) - (V(VCO_OUT_FB) > VDD_TYP/2 & V(VCO_OUT_FB, VCO_OUT_FB_DLY) < VDD_TYP/2) ) * 100m * (time > 100u) }
C_V_CTRL V_CTRL GND 10n ; Loop filter capacitor (dominant pole)
R_V_CTRL V_CTRL V_CTRL_FILT 1k ; Loop filter resistor (zero)
C_V_CTRL_FILT V_CTRL_FILT GND 1n ; Loop filter capacitor (second pole)

* Delay for edge detection in PFD
R_CLKIN_DLY CLKIN_BUF_OUT CLKIN_BUF_OUT_DLY 100
C_CLKIN_DLY CLKIN_BUF_OUT_DLY GND 10p

R_VCO_FB_DLY VCO_OUT_FB VCO_OUT_FB_DLY 100
C_VCO_FB_DLY VCO_OUT_FB_DLY GND 10p

* Voltage Controlled Oscillator (VCO)
* Frequency range: 24 MHz to 200 MHz
* V_CTRL = 0V -> Min Freq (e.g., 20MHz, slightly below min spec)
* V_CTRL = VDD_TYP -> Max Freq (e.g., 220MHz, slightly above max spec)
* Linear mapping: Freq = F_MIN + (F_MAX - F_MIN) * (V_CTRL / VDD_TYP)
.param F_VCO_MIN = 20M
.param F_VCO_MAX = 220M

B_VCO_FREQ VCO_FREQ_INST GND V = { (V(PD_EN_N) > VDD_TYP/2) ? (F_VCO_MIN + (F_VCO_MAX - F_VCO_MIN) * (V(V_CTRL_FILT) / VDD_TYP)) : 0 }

* VCO Output (Duty Cycle Corrected, 50%)
* Uses a behavioral source to generate a square wave at the VCO_FREQ_INST.
* The phase is integrated from the frequency.
B_VCO_OUT VCO_OUT GND V = { (V(PD_EN_N) > VDD_TYP/2) ? ( (sin(2*PI*idt(V(VCO_FREQ_INST))) > 0) ? VDD_TYP : 0 ) : 0 }

* Stabilization Time (100 µs)
* The PLL needs time to lock. The behavioral PFD/CP gain is zero until 100us.
* This is a simplified way to model the stabilization time. A real PLL would gradually lock.

* --- Output Buffers (CLKOUT, 1Y0-1Y3) ---
* Each output has a buffer chain to drive the load.
* CLKOUT is the direct output of the VCO.
* 1Y outputs are buffered copies of CLKOUT with 25 Ohm series resistors.

* CLKOUT Buffer (Co = 5.2 pF)
X_CLKOUT_BUF VCO_OUT CLKOUT VDD_3_3_V GND OUT_BUF_STRONG
C_CLKOUT_OUT CLKOUT GND 5.2p

* 1Y1 Buffer (Co = 2.8 pF, 25 Ohm series resistor)
X_1Y1_BUF VCO_OUT 1Y1_PRE VDD_3_3_V GND OUT_BUF_MEDIUM
R_1Y1_SERIES 1Y1_PRE 1Y1 25
C_1Y1_OUT 1Y1 GND 2.8p

* 1Y0 Buffer (Co = 2.8 pF, 25 Ohm series resistor)
X_1Y0_BUF VCO_OUT 1Y0_PRE VDD_3_3_V GND OUT_BUF_MEDIUM
R_1Y0_SERIES 1Y0_PRE 1Y0 25
C_1Y0_OUT 1Y0 GND 2.8p

* 1Y2 Buffer (Co = 2.8 pF, 25 Ohm series resistor)
X_1Y2_BUF VCO_OUT 1Y2_PRE VDD_3_3_V GND OUT_BUF_MEDIUM
R_1Y2_SERIES 1Y2_PRE 1Y2 25
C_1Y2_OUT 1Y2 GND 2.8p

* 1Y3 Buffer (Co = 2.8 pF, 25 Ohm series resistor)
X_1Y3_BUF VCO_OUT 1Y3_PRE VDD_3_3_V GND OUT_BUF_MEDIUM
R_1Y3_SERIES 1Y3_PRE 1Y3 25
C_1Y3_OUT 1Y3 GND 2.8p

* --- Output Buffer Subcircuits ---
* Generic inverter for buffer stages
.subckt INVERTER IN OUT VDD GND
M_P P OUT IN VDD PMOS W=10u L=0.18u
M_N N OUT IN GND NMOS W=5u L=0.18u
.ends INVERTER

* Medium strength output buffer (e.g., for 1Y outputs)
.subckt OUT_BUF_MEDIUM IN OUT VDD GND
X_INV1 IN INV1_OUT VDD GND INVERTER
X_INV2 INV1_OUT INV2_OUT VDD GND INVERTER W_P=20u W_N=10u
X_INV3 INV2_OUT OUT VDD GND INVERTER W_P=40u W_N=20u
.ends OUT_BUF_MEDIUM

* Strong strength output buffer (e.g., for CLKOUT if needed, or final stage of 1Y)
.subckt OUT_BUF_STRONG IN OUT VDD GND
X_INV1 IN INV1_OUT VDD GND INVERTER
X_INV2 INV1_OUT INV2_OUT VDD GND INVERTER W_P=30u W_N=15u
X_INV3 INV2_OUT OUT VDD GND INVERTER W_P=60u W_N=30u
.ends OUT_BUF_STRONG

.ends CDCVF2505_Q1
