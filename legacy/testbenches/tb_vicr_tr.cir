* TB10: Common-Mode Input Voltage Range (VICR)
.include "../models/lm741_transistor_level.sub"

Vcc vcc 0 DC 15
Vee vee 0 DC -15

Vin in_p 0 DC 0
X1 in_p out vcc vee out LM741_TRANSISTOR
RL out 0 2k
CL out 0 100p

.dc Vin -15 15 0.1

.meas dc Vicr_pos when V(out)=13.0
.meas dc Vicr_neg when V(out)=-12.0

.end
