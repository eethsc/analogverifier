* AC Open-Loop Testbench for CMOS Two-Stage Miller OpAmp
.include "../models/cmos_two_stage_opamp.sub"

Vdd vdd 0 DC 2.5
Vss vss 0 DC -2.5

Vin in_p 0 DC 0 AC 1.0

L_fb out in_m 100Meg
C_fb in_m 0 100Meg

* Pinout: 1:IN+  2:IN-  3:VDD  4:VSS  5:OUT
X1 in_p in_m vdd vss out CMOS_OPAMP

RL out 0 10k
CL out 0 20p

.ac dec 20 1 100Meg

.meas ac Avol_at_1Hz find V(out) at=1
.meas ac GBW when mag(V(out))=1.0
.meas ac Loop_at_GBW find V(out) when mag(V(out))=1.0

.end
