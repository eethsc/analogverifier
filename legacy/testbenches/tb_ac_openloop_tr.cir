* TB1: AC Open-Loop Frequency Response (Transistor-Level LM741)
.include "../models/lm741_transistor_level.sub"

Vcc vcc 0 DC 15
Vee vee 0 DC -15

Vin in_p 0 DC 0 AC 1.0

* L-C Servo loop for stable DC operating point and AC open-loop:
L_fb out in_m 100Meg
C_fb in_m 0 100Meg

* DUT Instance
* Pinout: 3:IN+  2:IN-  7:VCC  4:VEE  6:OUT
X1 in_p in_m vcc vee out LM741_TRANSISTOR

* Rated load
RL out 0 2k
CL out 0 100p

.ac dec 20 0.01 100Meg

.meas ac Avol_at_1Hz find V(out) at=1
.meas ac GBW when mag(V(out))=1.0
.meas ac Loop_at_GBW find V(out) when mag(V(out))=1.0

.end
