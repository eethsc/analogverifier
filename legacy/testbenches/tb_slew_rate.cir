* TB2: Large-Signal Slew Rate Testbench
* Measures: Slew Rate Positive (SR+), Slew Rate Negative (SR-)

.include "../models/lm741_macromodel.sub"

* Power Supplies
Vcc vcc 0 DC 15
Vee vee 0 DC -15

* Input Pulse: -10V to +10V, 10ns edges, 50us high, 100us period
Vin in_p 0 PULSE(-10 10 5u 10n 10n 50u 100u)

* DUT Instance in Unity-Gain Follower Configuration
X1 in_p out vcc vee out LM741_MACRO

* Load: Standard 2k ohm, 100pF
RL out 0 2k
CL out 0 100p

.tran 0 110u 0 50n

* Measure Rising Slew Rate (between -5V and +5V, span = 10V)
.meas tran t_r1 when V(out)=-5.0 rise=1
.meas tran t_r2 when V(out)=5.0 rise=1
.meas tran SR_pos param 10.0 / ((t_r2 - t_r1) * 1e6)

* Measure Falling Slew Rate (between +5V and -5V, span = 10V)
.meas tran t_f1 when V(out)=5.0 fall=1
.meas tran t_f2 when V(out)=-5.0 fall=1
.meas tran SR_neg param 10.0 / ((t_f2 - t_f1) * 1e6)

.end
