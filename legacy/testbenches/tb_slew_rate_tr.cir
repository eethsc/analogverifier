* TB2: Large-Signal Slew Rate (Transistor-Level LM741)
.include "../models/lm741_transistor_level.sub"

Vcc vcc 0 DC 15
Vee vee 0 DC -15

* Input step: -10V to +10V pulse
Vin in_p 0 PULSE(-10 10 5u 10n 10n 50u 100u)

* Follower: in_m tied to out
X1 in_p out vcc vee out LM741_TRANSISTOR

RL out 0 2k
CL out 0 100p

.tran 0 110u 0 50n

.meas tran t_r1 when V(out)=-5.0 rise=1
.meas tran t_r2 when V(out)=5.0 rise=1
.meas tran SR_pos param 10.0 / ((t_r2 - t_r1) * 1e6)

.meas tran t_f1 when V(out)=5.0 fall=1
.meas tran t_f2 when V(out)=-5.0 fall=1
.meas tran SR_neg param 10.0 / ((t_f2 - t_f1) * 1e6)

.end
