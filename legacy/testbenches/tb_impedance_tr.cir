* TB8: Differential Input Resistance and Open-Loop Output Resistance
.include "../models/lm741_transistor_level.sub"

* --- Part 1: Input Resistance ---
Vcc1 vcc1 0 DC 15
Vee1 vee1 0 DC -15
Vin_ac in_p1 in_m1 DC 0 AC 1.0
L_dc out1 in_m1 100Meg
C_ac in_m1 0 100Meg
X1 in_p1 in_m1 vcc1 vee1 out1 LM741_TRANSISTOR
RL1 out1 0 2k

* --- Part 2: Open-Loop Output Resistance ---
Vcc2 vcc2 0 DC 15
Vee2 vee2 0 DC -15
* Inputs DC biased at 0V
X2 0 0 vcc2 vee2 out2 LM741_TRANSISTOR
I_test 0 out2 DC 0 AC 1m

.ac dec 10 1 10k

* Differential input impedance at 10 Hz
.meas ac I_in find mag(I(Vin_ac)) at=10
.meas ac Rin_MOhm param 1.0 / (I_in * 1e6)

* Output impedance at 10 Hz: Rout = V(out2) / 1mA
.meas ac V_out2 find mag(V(out2)) at=10
.meas ac Rout_Ohm param V_out2 / 1e-3

.end
