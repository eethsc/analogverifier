* TB6: Output Voltage Swing Testbench
* Measures: Vom_pos (V) and Vom_neg (V) under RL = 2k

.include "../models/lm741_macromodel.sub"

* Power Supplies
Vcc vcc 0 DC 15
Vee vee 0 DC -15

* Input DC source swept from -15V to +15V
Vin in_p 0 DC 0

* Non-inverting configuration with Gain = 2
* Feedback network: Rf=10k, Rg=10k
Rf out in_m 10k
Rg in_m 0 10k

* DUT
X1 in_p in_m vcc vee out LM741_MACRO

* Rated Load
RL out 0 2k
CL out 0 100p

.dc Vin -15 15 0.1

* Maximum and Minimum Output Voltage
.meas dc Vom_pos max V(out)
.meas dc Vom_neg min V(out)

.end
