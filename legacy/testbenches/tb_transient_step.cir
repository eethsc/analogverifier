* TB7: Small-Signal Transient Step Response Testbench
* Measures: Peak voltage, Overshoot (%), Rise time (10% to 90%)

.include "../models/lm741_macromodel.sub"

* Power Supplies
Vcc vcc 0 DC 15
Vee vee 0 DC -15

* Small-signal pulse: 0 to 100mV, rise time 1ns, width 10us
Vin in_p 0 PULSE(0 100m 1u 1n 1n 10u 20u)

* Unity gain follower
X1 in_p out vcc vee out LM741_MACRO

* Rated Load
RL out 0 2k
CL out 0 100p

.tran 0 15u 0 10n

* Peak output voltage during step
.meas tran V_peak max V(out)
.meas tran Overshoot_pct param ((V_peak - 100m) / 100m) * 100.0

* Small-signal rise time (10mV to 90mV)
.meas tran t10 when V(out)=10m rise=1
.meas tran t90 when V(out)=90m rise=1
.meas tran Trise_ns param (t90 - t10) * 1e9

.end
