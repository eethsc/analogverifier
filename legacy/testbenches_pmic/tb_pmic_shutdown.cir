* Testbench: Shutdown Current and Enable Threshold
.include ../models/ti_lp2985_transistor.sub

V_IN in 0 DC 4.3
V_EN en 0 DC 0.0
C_IN in 0 1u
C_OUT out 0 4.7u
R_ESR out out_load 0.05
C_BYP byp 0 10n
R_LOAD out_load 0 3.3k

X_PMIC in 0 en byp out LP2985_33

.options gmin=1e-11 cshunt=1e-15 noopiter

.dc V_EN 0.0 2.5 0.05

.meas DC isd_ua FIND -I(V_IN)*1e6 AT 0.0
.meas DC von_th WHEN V(out_load)=1.65

.end
