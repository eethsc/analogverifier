* Standard Kuijk Bandgap with 5T OTA
.model QNPN NPN (IS=1e-15 BF=200 VAF=100)
.model MNMOS NMOS (LEVEL=1 VTO=0.7 KP=100u)
.model MPMOS PMOS (LEVEL=1 VTO=-0.7 KP=50u)

VCC vcc 0 DC 4.3

* Startup circuit: kicks Vbg if it is near 0
M_su n_gate_bg vcc vbg 0 MPMOS W=5u L=10u
R_su vcc vbg 500k

* Pass PMOS for Vbg
M_bg_pass vbg n_gate_bg vcc vcc MPMOS W=30u L=1u

* Two branches from Vbg
R0_a vbg node_a 58k
R0_b vbg node_b 58k

Q1 node_a 0 0 QNPN
Q2 node_b_e 0 0 QNPN 8
R1 node_b node_b_e 5.36k

* 5-Transistor OTA comparing node_a and node_b
* PMOS input pair (inputs ~ 0.65V)
M_in1 ota_out node_a ota_tail vcc MPMOS W=20u L=2u
M_in2 ota_c2  node_b ota_tail vcc MPMOS W=20u L=2u

* Tail current
R_tail vcc ota_tail 180k

* NMOS current mirror load
M_load1 ota_out ota_c2 0 0 MNMOS W=15u L=2u
M_load2 ota_c2  ota_c2 0 0 MNMOS W=15u L=2u

* Driver to pass PMOS gate
M_drv n_gate_bg ota_out 0 0 MNMOS W=20u L=1u
R_drv_pu vcc n_gate_bg 200k

C_comp n_gate_bg ota_out 15p

.op
.end
