* Testbench: Short-Circuit Current Limit
.include ../models/ti_lp2985_transistor.sub

V_IN in 0 DC 4.3
V_EN en 0 DC 3.3
C_IN in 0 1u
C_OUT out 0 4.7u
C_BYP byp 0 10n

* 0V voltage source shorting VOUT to measure short-circuit current
V_SHORT out 0 DC 0

X_PMIC in 0 en byp out LP2985_33

.nodeset V(byp)=1.07
.options gmin=1e-11 cshunt=1e-15 noopiter

.op

.meas OP isc_limit_ma PARAM abs(I(V_SHORT)) * 1e3

.end
