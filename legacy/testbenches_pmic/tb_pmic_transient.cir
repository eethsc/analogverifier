* Testbench: Transient Load Step Response (1mA to 150mA)
.include ../models/ti_lp2985_transistor.sub

V_IN in 0 DC 4.3
V_EN en 0 DC 3.3
C_IN in 0 1u
C_OUT out 0 4.7u
R_ESR out out_load 0.05
C_BYP byp 0 10n

* 1mA to 150mA load pulse with 1us rise and fall
I_LOAD out_load 0 PULSE(1m 150m 10u 1u 1u 50u 120u)

X_PMIC in 0 en byp out LP2985_33

.options gmin=1e-11 cshunt=1e-15 noopiter

.tran 0 100u 0 50n

.meas TRAN v_base AVG V(out_load) FROM 5u TO 9.9u
.meas TRAN v_dip MIN V(out_load) FROM 10u TO 30u
.meas TRAN tran_undershoot_mv PARAM (v_base - v_dip) * 1e3
.meas TRAN t_settle_hit WHEN V(out_load)=3.267 FALL=1
.meas TRAN t_settle_rec WHEN V(out_load)=3.267 RISE=1
.meas TRAN tran_settle_us PARAM (t_settle_rec - 10u) * 1e6

.end
