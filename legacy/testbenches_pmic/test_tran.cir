* Transient Load Step Test
.include ../models/ti_lp2985_transistor.sub
V_IN in 0 DC 4.3
V_EN en 0 DC 3.3
C_IN in 0 1u
C_OUT out 0 4.7u
R_ESR out out_load 0.05
C_BYP byp 0 10n
* Load step: 1mA to 150mA with 1us rise/fall
I_LOAD out_load 0 PULSE(1m 150m 10u 1u 1u 50u 120u)
X_PMIC in 0 en byp out LP2985_33

.tran 0 100u 0 50n

.meas TRAN v_baseline AVG V(out_load) FROM 5u TO 9.9u
.meas TRAN v_min MIN V(out_load) FROM 10u TO 30u
.meas TRAN v_max MAX V(out_load) FROM 60u TO 80u
.meas TRAN v_undershoot PARAM (v_baseline - v_min) * 1e3
.meas TRAN v_overshoot PARAM (v_max - v_baseline) * 1e3
.end
