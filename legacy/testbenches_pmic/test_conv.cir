* Test Convergence Speed
.include ../models/ti_lp2985_transistor.sub
V_IN in 0 DC 4.3
V_EN en 0 DC 3.3
C_IN in 0 1u
C_OUT out 0 4.7u
R_ESR out out_load 0.05
C_BYP byp 0 10n
R_LOAD out_load 0 3.3k
X_PMIC in 0 en byp out LP2985_33

.options gmin=1e-11 cshunt=1e-15 noopiter

.op
.meas OP vout_nom FIND V(out_load)
.end
