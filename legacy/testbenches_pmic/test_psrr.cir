* PSRR Test
.include ../models/ti_lp2985_transistor.sub
V_IN in 0 DC 4.3 AC 1.0
V_EN en 0 DC 3.3
C_IN in 0 1u
C_OUT out 0 4.7u
R_ESR out out_load 0.05
C_BYP byp 0 10n
R_LOAD out_load 0 66
X_PMIC in 0 en byp out LP2985_33
.ac dec 20 10 100k
.end
