* Self-Biased Supply-Independent Brokaw Bandgap
.model QNPN NPN (IS=1e-15 BF=200 VAF=200 CJC=1p CJE=2p TF=0.3n TR=6n)
.model QPNP PNP (IS=1e-15 BF=100 VAF=100 CJC=2p CJE=4p TF=0.5n TR=10n)
.model MNMOS NMOS (LEVEL=1 VTO=0.70 KP=120u LAMBDA=0.002)
.model MPMOS PMOS (LEVEL=1 VTO=-0.70 KP=60u LAMBDA=0.002)

VCC vcc 0 DC 4.3

* Cascode PMOS current mirror (ultra-high output impedance)
M_c1 c1 c1 vcc vcc MPMOS W=40u L=3u
M_c2 c2 c1 vcc vcc MPMOS W=40u L=3u
M_casc1 c1_casc v_casc c1 vcc MPMOS W=40u L=1.5u
M_casc2 c2_casc v_casc c2 vcc MPMOS W=40u L=1.5u

* Cascode bias
R_casc_b vcc v_casc 150k
Q_cb1 v_casc v_cb2 0 QNPN
Q_cb2 v_cb2 0 0 QNPN

* NPN core
Q1 c1_casc vbg e1 QNPN
Q2 c2_casc vbg e2 QNPN 8
R_dvbe e2 e1 320
R_sum e1 0 5.8k

* Differential error amp equalizing c1_casc and c2_casc
M_d1 out_d c1_casc d_tail 0 MNMOS W=30u L=2u
M_d2 d_c2  c2_casc d_tail 0 MNMOS W=30u L=2u
R_dtail d_tail 0 80k

M_dl1 out_d d_c2 vcc vcc MPMOS W=30u L=2u
M_dl2 d_c2  d_c2 vcc vcc MPMOS W=30u L=2u

* Driver to Vbg
M_drv vbg out_d 0 0 MNMOS W=20u L=1u
R_bg_pull vcc vbg 100k
C_comp out_d vbg 20p

.dc VCC 3.8 10.0 0.5
.end
