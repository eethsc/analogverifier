* Line Regulation Test
.include ../models/ti_lp2985_transistor.sub
V_IN in 0 DC 4.3
V_EN en 0 DC 3.3
C_IN in 0 1u
C_OUT out 0 4.7u
R_ESR out out_load 0.05
C_BYP byp 0 10n
I_LOAD out_load 0 DC 1m
X_PMIC in 0 en byp out LP2985_33
.dc V_IN 3.8 10.0 0.1
.end
