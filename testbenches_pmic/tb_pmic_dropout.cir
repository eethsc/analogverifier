* Testbench: Dropout Voltage across 3 load conditions (150mA, 50mA, 1mA)
.include ../models/ti_lp2985_transistor.sub

V_IN in 0 DC 4.3
V_EN en 0 DC 3.3
C_IN in 0 1u

* 150mA Load Branch (R=22)
C_OUT1 out1 0 4.7u
R_ESR1 out1 out_load_150 0.05
C_BYP1 byp1 0 10n
R_LOAD_150 out_load_150 0 22
X_PMIC_150 in 0 en byp1 out1 LP2985_33

* 50mA Load Branch (R=66)
C_OUT2 out2 0 4.7u
R_ESR2 out2 out_load_50 0.05
C_BYP2 byp2 0 10n
R_LOAD_50 out_load_50 0 66
X_PMIC_50 in 0 en byp2 out2 LP2985_33

* 1mA Load Branch (R=3300)
C_OUT3 out3 0 4.7u
R_ESR3 out3 out_load_1 0.05
C_BYP3 byp3 0 10n
R_LOAD_1 out_load_1 0 3300
X_PMIC_1 in 0 en byp3 out3 LP2985_33

.nodeset V(out1)=3.2 V(out2)=3.2 V(out3)=3.2
.options gmin=1e-11 cshunt=1e-15 noopiter

.dc V_IN 3.1 3.8 0.02

.meas DC vin_150 WHEN V(out_load_150)=3.20
.meas DC vin_50  WHEN V(out_load_50)=3.20
.meas DC vin_1   WHEN V(out_load_1)=3.20

.meas DC vdo_150ma_mv PARAM (vin_150 - 3.20) * 1e3
.meas DC vdo_50ma_mv  PARAM (vin_50  - 3.20) * 1e3
.meas DC vdo_1ma_mv   PARAM (vin_1   - 3.20) * 1e3

.end
