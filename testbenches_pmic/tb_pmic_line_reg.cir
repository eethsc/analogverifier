* Line Reg Test
.include ../models/ti_lp2985_transistor.sub
V_IN in 0 DC 4.3
V_EN en 0 DC 3.3
C_IN in 0 1u
C_OUT out 0 4.7u
R_ESR out out_load 0.05
C_BYP byp 0 10n
R_LOAD out_load 0 3.3k
X_PMIC in 0 en byp out LP2985_33

.nodeset V(out)=3.3 V(byp)=1.18 V(X_PMIC.n_gate)=3.5

.dc V_IN 3.8 10.0 0.5

.meas DC vout_min MIN V(out_load)
.meas DC vout_max MAX V(out_load)
.meas DC line_reg_pct_v PARAM ((vout_max - vout_min) / 3.30) / (10.0 - 3.8) * 100
.end
