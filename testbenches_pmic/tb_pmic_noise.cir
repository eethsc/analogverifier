* Testbench: Output Voltage Noise (10Hz to 100kHz)
.include ../models/ti_lp2985_transistor.sub

V_IN in 0 DC 4.3
V_EN en 0 DC 3.3
C_IN in 0 1u
C_OUT out 0 4.7u
R_ESR out out_load 0.05
C_BYP byp 0 10n
R_LOAD out_load 0 330

X_PMIC in 0 en byp out LP2985_33

.nodeset V(out)=3.3 V(byp)=1.18 V(X_PMIC.n_gate)=3.5
.options gmin=1e-11 cshunt=1e-15 noopiter

.noise V(out_load) V_IN dec 20 10 100k

.meas NOISE onoise_total_v INTEG V(onoise) FROM 10 TO 100k
.meas NOISE onoise_total_uv PARAM onoise_total_v * 1e6

.end
