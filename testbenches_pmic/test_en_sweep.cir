* Enable Threshold Sweep
.include ../models/ti_lp2985_transistor.sub
V_IN in 0 DC 4.3
V_EN en 0 DC 0.0
C_IN in 0 1u
C_OUT out 0 4.7u
C_BYP byp 0 10n
R_LOAD out 0 3.3k
X_PMIC in 0 en byp out LP2985_33
.dc V_EN 0.0 2.5 0.05
.end
