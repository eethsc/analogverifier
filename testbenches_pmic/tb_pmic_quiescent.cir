* Testbench: Ground Pin Current at Light and Full Load
.include ../models/ti_lp2985_transistor.sub

V_EN en 0 DC 3.3

* 1mA Light Load Branch
V_IN1 in1 0 DC 4.3
C_IN1 in1 0 1u
C_OUT1 out1 0 4.7u
R_ESR1 out1 out_load_1 0.05
C_BYP1 byp1 0 10n
R_LOAD1 out_load_1 0 3300
X_PMIC1 in1 0 en byp1 out1 LP2985_33

* 150mA Full Load Branch
V_IN2 in2 0 DC 4.3
C_IN2 in2 0 1u
C_OUT2 out2 0 4.7u
R_ESR2 out2 out_load_150 0.05
C_BYP2 byp2 0 10n
R_LOAD2 out_load_150 0 22
X_PMIC2 in2 0 en byp2 out2 LP2985_33

.nodeset V(out1)=3.3 V(out2)=3.3 V(byp1)=1.07 V(byp2)=1.07
.options gmin=1e-11 cshunt=1e-15 noopiter

.op

.meas OP ignd_1ma_ua   PARAM (-I(V_IN1) - V(out_load_1)/3300) * 1e6
.meas OP ignd_150ma_ua PARAM (-I(V_IN2) - V(out_load_150)/22) * 1e6

.end
