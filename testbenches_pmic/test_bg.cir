* Test Bandgap Core
.model QNPN NPN (IS=1e-15 BF=200 VAF=100)
.model QPNP PNP (IS=1e-15 BF=100 VAF=50)
.model MNMOS NMOS (LEVEL=1 VTO=0.7 KP=100u)
.model MPMOS PMOS (LEVEL=1 VTO=-0.7 KP=50u)

VCC vcc 0 DC 4.3

* Current mirror on top
M1 c1 c1 vcc vcc MPMOS W=30u L=2u
M2 c2 c1 vcc vcc MPMOS W=30u L=2u

* NPN pair
Q1 c1 vbg e1 QNPN
Q2 c2 vbg e2 QNPN 8

R1 e2 e1 1.0k
R2 e1 0 6.0k

* Differential feedback stage to equalize c1 and c2
* Q_diff pair comparing c1 and c2
Q_d1 out_diff c1 tail 0 QNPN
Q_d2 out_d2   c2 tail 0 QNPN
R_c1 vcc out_diff 100k
R_c2 vcc out_d2 100k
R_tail tail 0 100k

* Buffer to drive vbg
M_drv vbg out_diff 0 0 MNMOS W=30u L=1u
R_bg_pull vcc vbg 50k
C_comp out_diff vbg 20p

.op
.end
