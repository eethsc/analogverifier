* Short Circuit Current Test
.include ../models/ti_lp2985_transistor.sub
V_IN in 0 DC 4.3
V_EN en 0 DC 3.3
C_IN in 0 1u
C_OUT out 0 4.7u
C_BYP byp 0 10n
* Short VOUT directly through a 0V voltage source to measure current
V_SHORT out 0 DC 0
X_PMIC in 0 en byp out LP2985_33
.op
.end
